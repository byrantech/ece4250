* SPICE3 file created from full.ext - technology: scmos

.option scale=0.09u

M1000 fsm_0/or4_0/nand2_0/A h3 fsm_0/or4_0/nor2_0/a_11_35# Vdd pfet w=18 l=2
+  ad=108 pd=48 as=126 ps=50
M1001 fsm_0/or4_0/nand2_0/A h2 GND GND nfet w=12 l=2
+  ad=84 pd=38 as=27870 ps=19178
M1002 GND h3 fsm_0/or4_0/nand2_0/A GND nfet w=12 l=2
+  ad=0 pd=0 as=0 ps=0
M1003 fsm_0/or4_0/nor2_0/a_11_35# h2 Vdd Vdd pfet w=18 l=2
+  ad=0 pd=0 as=79448 ps=37002
M1004 fsm_0/or4_0/nand2_0/B h4 fsm_0/or4_0/nor2_2/a_11_35# Vdd pfet w=18 l=2
+  ad=108 pd=48 as=126 ps=50
M1005 fsm_0/or4_0/nand2_0/B GND GND GND nfet w=12 l=2
+  ad=84 pd=38 as=0 ps=0
M1006 GND h4 fsm_0/or4_0/nand2_0/B GND nfet w=12 l=2
+  ad=0 pd=0 as=0 ps=0
M1007 fsm_0/or4_0/nor2_2/a_11_35# GND Vdd Vdd pfet w=18 l=2
+  ad=0 pd=0 as=0 ps=0
M1008 fsm_0/or4_0/nand2_0/a_7_10# fsm_0/or4_0/nand2_0/A GND GND nfet w=6 l=2
+  ad=42 pd=26 as=0 ps=0
M1009 fsm_0/or4_0/out fsm_0/or4_0/nand2_0/A Vdd Vdd pfet w=12 l=2
+  ad=84 pd=38 as=0 ps=0
M1010 fsm_0/or4_0/out fsm_0/or4_0/nand2_0/B fsm_0/or4_0/nand2_0/a_7_10# GND nfet w=6 l=2
+  ad=36 pd=24 as=0 ps=0
M1011 Vdd fsm_0/or4_0/nand2_0/B fsm_0/or4_0/out Vdd pfet w=12 l=2
+  ad=0 pd=0 as=0 ps=0
M1012 fsm_0/or4_1/nand2_0/A h2 fsm_0/or4_1/nor2_0/a_11_35# Vdd pfet w=18 l=2
+  ad=108 pd=48 as=126 ps=50
M1013 fsm_0/or4_1/nand2_0/A h4 GND GND nfet w=12 l=2
+  ad=84 pd=38 as=0 ps=0
M1014 GND h2 fsm_0/or4_1/nand2_0/A GND nfet w=12 l=2
+  ad=0 pd=0 as=0 ps=0
M1015 fsm_0/or4_1/nor2_0/a_11_35# h4 Vdd Vdd pfet w=18 l=2
+  ad=0 pd=0 as=0 ps=0
M1016 fsm_0/inv_0/in h5 fsm_0/or4_1/nor2_2/a_11_35# Vdd pfet w=18 l=2
+  ad=108 pd=48 as=126 ps=50
M1017 fsm_0/inv_0/in h6 GND GND nfet w=12 l=2
+  ad=84 pd=38 as=0 ps=0
M1018 GND h5 fsm_0/inv_0/in GND nfet w=12 l=2
+  ad=0 pd=0 as=0 ps=0
M1019 fsm_0/or4_1/nor2_2/a_11_35# h6 Vdd Vdd pfet w=18 l=2
+  ad=0 pd=0 as=0 ps=0
M1020 fsm_0/or4_1/nand2_0/a_7_10# fsm_0/or4_1/nand2_0/A GND GND nfet w=6 l=2
+  ad=42 pd=26 as=0 ps=0
M1021 fsm_0/and2_2/B fsm_0/or4_1/nand2_0/A Vdd Vdd pfet w=12 l=2
+  ad=84 pd=38 as=0 ps=0
M1022 fsm_0/and2_2/B fsm_0/inv_0/in fsm_0/or4_1/nand2_0/a_7_10# GND nfet w=6 l=2
+  ad=36 pd=24 as=0 ps=0
M1023 Vdd fsm_0/inv_0/in fsm_0/and2_2/B Vdd pfet w=12 l=2
+  ad=0 pd=0 as=0 ps=0
M1024 fsm_0/or4_2/nand2_0/A h4 fsm_0/or4_2/nor2_0/a_11_35# Vdd pfet w=18 l=2
+  ad=108 pd=48 as=126 ps=50
M1025 fsm_0/or4_2/nand2_0/A h6 GND GND nfet w=12 l=2
+  ad=84 pd=38 as=0 ps=0
M1026 GND h4 fsm_0/or4_2/nand2_0/A GND nfet w=12 l=2
+  ad=0 pd=0 as=0 ps=0
M1027 fsm_0/or4_2/nor2_0/a_11_35# h6 Vdd Vdd pfet w=18 l=2
+  ad=0 pd=0 as=0 ps=0
M1028 fsm_0/or4_2/nand2_0/B h2 fsm_0/or4_2/nor2_2/a_11_35# Vdd pfet w=18 l=2
+  ad=108 pd=48 as=126 ps=50
M1029 fsm_0/or4_2/nand2_0/B GND GND GND nfet w=12 l=2
+  ad=84 pd=38 as=0 ps=0
M1030 GND h2 fsm_0/or4_2/nand2_0/B GND nfet w=12 l=2
+  ad=0 pd=0 as=0 ps=0
M1031 fsm_0/or4_2/nor2_2/a_11_35# GND Vdd Vdd pfet w=18 l=2
+  ad=0 pd=0 as=0 ps=0
M1032 fsm_0/or4_2/nand2_0/a_7_10# fsm_0/or4_2/nand2_0/A GND GND nfet w=6 l=2
+  ad=42 pd=26 as=0 ps=0
M1033 fsm_0/rd fsm_0/or4_2/nand2_0/A Vdd Vdd pfet w=12 l=2
+  ad=84 pd=38 as=0 ps=0
M1034 fsm_0/rd fsm_0/or4_2/nand2_0/B fsm_0/or4_2/nand2_0/a_7_10# GND nfet w=6 l=2
+  ad=36 pd=24 as=0 ps=0
M1035 Vdd fsm_0/or4_2/nand2_0/B fsm_0/rd Vdd pfet w=12 l=2
+  ad=0 pd=0 as=0 ps=0
M1036 fsm_0/fsm_states_0/or4_0/nand2_0/A h4 fsm_0/fsm_states_0/or4_0/nor2_0/a_11_35# Vdd pfet w=18 l=2
+  ad=108 pd=48 as=126 ps=50
M1037 fsm_0/fsm_states_0/or4_0/nand2_0/A h6 GND GND nfet w=12 l=2
+  ad=84 pd=38 as=0 ps=0
M1038 GND h4 fsm_0/fsm_states_0/or4_0/nand2_0/A GND nfet w=12 l=2
+  ad=0 pd=0 as=0 ps=0
M1039 fsm_0/fsm_states_0/or4_0/nor2_0/a_11_35# h6 Vdd Vdd pfet w=18 l=2
+  ad=0 pd=0 as=0 ps=0
M1040 fsm_0/fsm_states_0/or4_0/nand2_0/B fsm_0/t1 fsm_0/fsm_states_0/or4_0/nor2_2/a_11_35# Vdd pfet w=18 l=2
+  ad=108 pd=48 as=126 ps=50
M1041 fsm_0/fsm_states_0/or4_0/nand2_0/B h2 GND GND nfet w=12 l=2
+  ad=84 pd=38 as=0 ps=0
M1042 GND fsm_0/t1 fsm_0/fsm_states_0/or4_0/nand2_0/B GND nfet w=12 l=2
+  ad=0 pd=0 as=0 ps=0
M1043 fsm_0/fsm_states_0/or4_0/nor2_2/a_11_35# h2 Vdd Vdd pfet w=18 l=2
+  ad=0 pd=0 as=0 ps=0
M1044 fsm_0/fsm_states_0/or4_0/nand2_0/a_7_10# fsm_0/fsm_states_0/or4_0/nand2_0/A GND GND nfet w=6 l=2
+  ad=42 pd=26 as=0 ps=0
M1045 fsm_0/fsm_states_0/and2_0/B fsm_0/fsm_states_0/or4_0/nand2_0/A Vdd Vdd pfet w=12 l=2
+  ad=84 pd=38 as=0 ps=0
M1046 fsm_0/fsm_states_0/and2_0/B fsm_0/fsm_states_0/or4_0/nand2_0/B fsm_0/fsm_states_0/or4_0/nand2_0/a_7_10# GND nfet w=6 l=2
+  ad=36 pd=24 as=0 ps=0
M1047 Vdd fsm_0/fsm_states_0/or4_0/nand2_0/B fsm_0/fsm_states_0/and2_0/B Vdd pfet w=12 l=2
+  ad=0 pd=0 as=0 ps=0
M1048 fsm_0/fsm_states_0/_reset nh2 GND GND nfet w=5 l=2
+  ad=30 pd=22 as=0 ps=0
M1049 fsm_0/fsm_states_0/_reset nh2 Vdd Vdd pfet w=10 l=2
+  ad=60 pd=32 as=0 ps=0
M1050 fsm_0/fsm_states_0/and2_2/A LOAD GND GND nfet w=5 l=2
+  ad=30 pd=22 as=0 ps=0
M1051 fsm_0/fsm_states_0/and2_2/A LOAD Vdd Vdd pfet w=10 l=2
+  ad=60 pd=32 as=0 ps=0
M1052 fsm_0/fsm_states_0/_iter ITER GND GND nfet w=5 l=2
+  ad=30 pd=22 as=0 ps=0
M1053 fsm_0/fsm_states_0/_iter ITER Vdd Vdd pfet w=10 l=2
+  ad=60 pd=32 as=0 ps=0
M1054 GND fsm_0/fsm_states_0/and2_0/a_1_6# nh1 GND nfet w=6 l=2
+  ad=0 pd=0 as=42 ps=26
M1055 fsm_0/fsm_states_0/and2_0/a_1_6# fsm_0/fsm_states_0/_reset Vdd Vdd pfet w=12 l=2
+  ad=84 pd=38 as=0 ps=0
M1056 fsm_0/fsm_states_0/and2_0/a_14_9# fsm_0/fsm_states_0/_reset GND GND nfet w=6 l=2
+  ad=42 pd=26 as=0 ps=0
M1057 Vdd fsm_0/fsm_states_0/and2_0/a_1_6# nh1 Vdd pfet w=12 l=2
+  ad=0 pd=0 as=84 ps=38
M1058 Vdd fsm_0/fsm_states_0/and2_0/B fsm_0/fsm_states_0/and2_0/a_1_6# Vdd pfet w=12 l=2
+  ad=0 pd=0 as=0 ps=0
M1059 fsm_0/fsm_states_0/and2_0/a_1_6# fsm_0/fsm_states_0/and2_0/B fsm_0/fsm_states_0/and2_0/a_14_9# GND nfet w=6 l=2
+  ad=36 pd=24 as=0 ps=0
M1060 GND fsm_0/fsm_states_0/and2_1/a_1_6# fsm_0/t1 GND nfet w=6 l=2
+  ad=0 pd=0 as=42 ps=26
M1061 fsm_0/fsm_states_0/and2_1/a_1_6# h1 Vdd Vdd pfet w=12 l=2
+  ad=84 pd=38 as=0 ps=0
M1062 fsm_0/fsm_states_0/and2_1/a_14_9# h1 GND GND nfet w=6 l=2
+  ad=42 pd=26 as=0 ps=0
M1063 Vdd fsm_0/fsm_states_0/and2_1/a_1_6# fsm_0/t1 Vdd pfet w=12 l=2
+  ad=0 pd=0 as=84 ps=38
M1064 Vdd fsm_0/fsm_states_0/and2_1/B fsm_0/fsm_states_0/and2_1/a_1_6# Vdd pfet w=12 l=2
+  ad=0 pd=0 as=0 ps=0
M1065 fsm_0/fsm_states_0/and2_1/a_1_6# fsm_0/fsm_states_0/and2_1/B fsm_0/fsm_states_0/and2_1/a_14_9# GND nfet w=6 l=2
+  ad=36 pd=24 as=0 ps=0
M1066 GND fsm_0/fsm_states_0/and2_2/a_1_6# fsm_0/fsm_states_0/and2_1/B GND nfet w=6 l=2
+  ad=0 pd=0 as=42 ps=26
M1067 fsm_0/fsm_states_0/and2_2/a_1_6# fsm_0/fsm_states_0/and2_2/A Vdd Vdd pfet w=12 l=2
+  ad=84 pd=38 as=0 ps=0
M1068 fsm_0/fsm_states_0/and2_2/a_14_9# fsm_0/fsm_states_0/and2_2/A GND GND nfet w=6 l=2
+  ad=42 pd=26 as=0 ps=0
M1069 Vdd fsm_0/fsm_states_0/and2_2/a_1_6# fsm_0/fsm_states_0/and2_1/B Vdd pfet w=12 l=2
+  ad=0 pd=0 as=84 ps=38
M1070 Vdd fsm_0/fsm_states_0/_iter fsm_0/fsm_states_0/and2_2/a_1_6# Vdd pfet w=12 l=2
+  ad=0 pd=0 as=0 ps=0
M1071 fsm_0/fsm_states_0/and2_2/a_1_6# fsm_0/fsm_states_0/_iter fsm_0/fsm_states_0/and2_2/a_14_9# GND nfet w=6 l=2
+  ad=36 pd=24 as=0 ps=0
M1072 GND fsm_0/fsm_states_0/and2_3/a_1_6# nh3 GND nfet w=6 l=2
+  ad=0 pd=0 as=42 ps=26
M1073 fsm_0/fsm_states_0/and2_3/a_1_6# fsm_0/fsm_states_0/_reset Vdd Vdd pfet w=12 l=2
+  ad=84 pd=38 as=0 ps=0
M1074 fsm_0/fsm_states_0/and2_3/a_14_9# fsm_0/fsm_states_0/_reset GND GND nfet w=6 l=2
+  ad=42 pd=26 as=0 ps=0
M1075 Vdd fsm_0/fsm_states_0/and2_3/a_1_6# nh3 Vdd pfet w=12 l=2
+  ad=0 pd=0 as=84 ps=38
M1076 Vdd fsm_0/fsm_states_0/and2_3/B fsm_0/fsm_states_0/and2_3/a_1_6# Vdd pfet w=12 l=2
+  ad=0 pd=0 as=0 ps=0
M1077 fsm_0/fsm_states_0/and2_3/a_1_6# fsm_0/fsm_states_0/and2_3/B fsm_0/fsm_states_0/and2_3/a_14_9# GND nfet w=6 l=2
+  ad=36 pd=24 as=0 ps=0
M1078 GND fsm_0/fsm_states_0/and2_4/a_1_6# fsm_0/fsm_states_0/and2_3/B GND nfet w=6 l=2
+  ad=0 pd=0 as=42 ps=26
M1079 fsm_0/fsm_states_0/and2_4/a_1_6# h1 Vdd Vdd pfet w=12 l=2
+  ad=84 pd=38 as=0 ps=0
M1080 fsm_0/fsm_states_0/and2_4/a_14_9# h1 GND GND nfet w=6 l=2
+  ad=42 pd=26 as=0 ps=0
M1081 Vdd fsm_0/fsm_states_0/and2_4/a_1_6# fsm_0/fsm_states_0/and2_3/B Vdd pfet w=12 l=2
+  ad=0 pd=0 as=84 ps=38
M1082 Vdd LOAD fsm_0/fsm_states_0/and2_4/a_1_6# Vdd pfet w=12 l=2
+  ad=0 pd=0 as=0 ps=0
M1083 fsm_0/fsm_states_0/and2_4/a_1_6# LOAD fsm_0/fsm_states_0/and2_4/a_14_9# GND nfet w=6 l=2
+  ad=36 pd=24 as=0 ps=0
M1084 GND PHI1 fsm_0/fsm_states_0/new_latch_0[0]/a_82_52# GND nfet w=5 l=2
+  ad=0 pd=0 as=30 ps=22
M1085 fsm_0/fsm_states_0/new_latch_0[0]/a_99_34# fsm_0/fsm_states_0/new_latch_0[0]/a_79_32# Vdd Vdd pfet w=10 l=2
+  ad=40 pd=28 as=0 ps=0
M1086 fsm_0/fsm_states_0/new_latch_0[0]/a_79_32# fsm_0/ih6 Vdd Vdd pfet w=10 l=2
+  ad=60 pd=32 as=0 ps=0
M1087 h6 fsm_0/fsm_states_0/new_latch_0[0]/a_82_52# fsm_0/fsm_states_0/new_latch_0[0]/a_99_34# Vdd pfet w=10 l=2
+  ad=60 pd=32 as=0 ps=0
M1088 fsm_0/fsm_states_0/new_latch_0[0]/a_82_34# fsm_0/fsm_states_0/new_latch_0[0]/a_79_32# GND GND nfet w=5 l=2
+  ad=20 pd=18 as=0 ps=0
M1089 fsm_0/fsm_states_0/new_latch_0[0]/a_79_32# fsm_0/ih6 GND GND nfet w=5 l=2
+  ad=30 pd=22 as=0 ps=0
M1090 h6 PHI1 fsm_0/fsm_states_0/new_latch_0[0]/a_82_34# GND nfet w=5 l=2
+  ad=30 pd=22 as=0 ps=0
M1091 Vdd PHI1 fsm_0/fsm_states_0/new_latch_0[0]/a_82_52# Vdd pfet w=10 l=2
+  ad=0 pd=0 as=60 ps=32
M1092 GND PHI1 fsm_0/fsm_states_0/new_latch_0[1]/a_82_52# GND nfet w=5 l=2
+  ad=0 pd=0 as=30 ps=22
M1093 fsm_0/fsm_states_0/new_latch_0[1]/a_99_34# fsm_0/fsm_states_0/new_latch_0[1]/a_79_32# Vdd Vdd pfet w=10 l=2
+  ad=40 pd=28 as=0 ps=0
M1094 fsm_0/fsm_states_0/new_latch_0[1]/a_79_32# fsm_0/ih5 Vdd Vdd pfet w=10 l=2
+  ad=60 pd=32 as=0 ps=0
M1095 h5 fsm_0/fsm_states_0/new_latch_0[1]/a_82_52# fsm_0/fsm_states_0/new_latch_0[1]/a_99_34# Vdd pfet w=10 l=2
+  ad=60 pd=32 as=0 ps=0
M1096 fsm_0/fsm_states_0/new_latch_0[1]/a_82_34# fsm_0/fsm_states_0/new_latch_0[1]/a_79_32# GND GND nfet w=5 l=2
+  ad=20 pd=18 as=0 ps=0
M1097 fsm_0/fsm_states_0/new_latch_0[1]/a_79_32# fsm_0/ih5 GND GND nfet w=5 l=2
+  ad=30 pd=22 as=0 ps=0
M1098 h5 PHI1 fsm_0/fsm_states_0/new_latch_0[1]/a_82_34# GND nfet w=5 l=2
+  ad=30 pd=22 as=0 ps=0
M1099 Vdd PHI1 fsm_0/fsm_states_0/new_latch_0[1]/a_82_52# Vdd pfet w=10 l=2
+  ad=0 pd=0 as=60 ps=32
M1100 GND PHI1 fsm_0/fsm_states_0/new_latch_0[2]/a_82_52# GND nfet w=5 l=2
+  ad=0 pd=0 as=30 ps=22
M1101 fsm_0/fsm_states_0/new_latch_0[2]/a_99_34# fsm_0/fsm_states_0/new_latch_0[2]/a_79_32# Vdd Vdd pfet w=10 l=2
+  ad=40 pd=28 as=0 ps=0
M1102 fsm_0/fsm_states_0/new_latch_0[2]/a_79_32# fsm_0/ih4 Vdd Vdd pfet w=10 l=2
+  ad=60 pd=32 as=0 ps=0
M1103 h4 fsm_0/fsm_states_0/new_latch_0[2]/a_82_52# fsm_0/fsm_states_0/new_latch_0[2]/a_99_34# Vdd pfet w=10 l=2
+  ad=60 pd=32 as=0 ps=0
M1104 fsm_0/fsm_states_0/new_latch_0[2]/a_82_34# fsm_0/fsm_states_0/new_latch_0[2]/a_79_32# GND GND nfet w=5 l=2
+  ad=20 pd=18 as=0 ps=0
M1105 fsm_0/fsm_states_0/new_latch_0[2]/a_79_32# fsm_0/ih4 GND GND nfet w=5 l=2
+  ad=30 pd=22 as=0 ps=0
M1106 h4 PHI1 fsm_0/fsm_states_0/new_latch_0[2]/a_82_34# GND nfet w=5 l=2
+  ad=30 pd=22 as=0 ps=0
M1107 Vdd PHI1 fsm_0/fsm_states_0/new_latch_0[2]/a_82_52# Vdd pfet w=10 l=2
+  ad=0 pd=0 as=60 ps=32
M1108 GND PHI1 fsm_0/fsm_states_0/new_latch_0[3]/a_82_52# GND nfet w=5 l=2
+  ad=0 pd=0 as=30 ps=22
M1109 fsm_0/fsm_states_0/new_latch_0[3]/a_99_34# fsm_0/fsm_states_0/new_latch_0[3]/a_79_32# Vdd Vdd pfet w=10 l=2
+  ad=40 pd=28 as=0 ps=0
M1110 fsm_0/fsm_states_0/new_latch_0[3]/a_79_32# fsm_0/ih3 Vdd Vdd pfet w=10 l=2
+  ad=60 pd=32 as=0 ps=0
M1111 h3 fsm_0/fsm_states_0/new_latch_0[3]/a_82_52# fsm_0/fsm_states_0/new_latch_0[3]/a_99_34# Vdd pfet w=10 l=2
+  ad=60 pd=32 as=0 ps=0
M1112 fsm_0/fsm_states_0/new_latch_0[3]/a_82_34# fsm_0/fsm_states_0/new_latch_0[3]/a_79_32# GND GND nfet w=5 l=2
+  ad=20 pd=18 as=0 ps=0
M1113 fsm_0/fsm_states_0/new_latch_0[3]/a_79_32# fsm_0/ih3 GND GND nfet w=5 l=2
+  ad=30 pd=22 as=0 ps=0
M1114 h3 PHI1 fsm_0/fsm_states_0/new_latch_0[3]/a_82_34# GND nfet w=5 l=2
+  ad=30 pd=22 as=0 ps=0
M1115 Vdd PHI1 fsm_0/fsm_states_0/new_latch_0[3]/a_82_52# Vdd pfet w=10 l=2
+  ad=0 pd=0 as=60 ps=32
M1116 GND PHI1 fsm_0/fsm_states_0/new_latch_0[4]/a_82_52# GND nfet w=5 l=2
+  ad=0 pd=0 as=30 ps=22
M1117 fsm_0/fsm_states_0/new_latch_0[4]/a_99_34# fsm_0/fsm_states_0/new_latch_0[4]/a_79_32# Vdd Vdd pfet w=10 l=2
+  ad=40 pd=28 as=0 ps=0
M1118 fsm_0/fsm_states_0/new_latch_0[4]/a_79_32# fsm_0/ih2 Vdd Vdd pfet w=10 l=2
+  ad=60 pd=32 as=0 ps=0
M1119 h2 fsm_0/fsm_states_0/new_latch_0[4]/a_82_52# fsm_0/fsm_states_0/new_latch_0[4]/a_99_34# Vdd pfet w=10 l=2
+  ad=60 pd=32 as=0 ps=0
M1120 fsm_0/fsm_states_0/new_latch_0[4]/a_82_34# fsm_0/fsm_states_0/new_latch_0[4]/a_79_32# GND GND nfet w=5 l=2
+  ad=20 pd=18 as=0 ps=0
M1121 fsm_0/fsm_states_0/new_latch_0[4]/a_79_32# fsm_0/ih2 GND GND nfet w=5 l=2
+  ad=30 pd=22 as=0 ps=0
M1122 h2 PHI1 fsm_0/fsm_states_0/new_latch_0[4]/a_82_34# GND nfet w=5 l=2
+  ad=30 pd=22 as=0 ps=0
M1123 Vdd PHI1 fsm_0/fsm_states_0/new_latch_0[4]/a_82_52# Vdd pfet w=10 l=2
+  ad=0 pd=0 as=60 ps=32
M1124 GND PHI1 fsm_0/fsm_states_0/new_latch_0[5]/a_82_52# GND nfet w=5 l=2
+  ad=0 pd=0 as=30 ps=22
M1125 fsm_0/fsm_states_0/new_latch_0[5]/a_99_34# fsm_0/fsm_states_0/new_latch_0[5]/a_79_32# Vdd Vdd pfet w=10 l=2
+  ad=40 pd=28 as=0 ps=0
M1126 fsm_0/fsm_states_0/new_latch_0[5]/a_79_32# fsm_0/ih1 Vdd Vdd pfet w=10 l=2
+  ad=60 pd=32 as=0 ps=0
M1127 h1 fsm_0/fsm_states_0/new_latch_0[5]/a_82_52# fsm_0/fsm_states_0/new_latch_0[5]/a_99_34# Vdd pfet w=10 l=2
+  ad=60 pd=32 as=0 ps=0
M1128 fsm_0/fsm_states_0/new_latch_0[5]/a_82_34# fsm_0/fsm_states_0/new_latch_0[5]/a_79_32# GND GND nfet w=5 l=2
+  ad=20 pd=18 as=0 ps=0
M1129 fsm_0/fsm_states_0/new_latch_0[5]/a_79_32# fsm_0/ih1 GND GND nfet w=5 l=2
+  ad=30 pd=22 as=0 ps=0
M1130 h1 PHI1 fsm_0/fsm_states_0/new_latch_0[5]/a_82_34# GND nfet w=5 l=2
+  ad=30 pd=22 as=0 ps=0
M1131 Vdd PHI1 fsm_0/fsm_states_0/new_latch_0[5]/a_82_52# Vdd pfet w=10 l=2
+  ad=0 pd=0 as=60 ps=32
M1132 GND fsm_0/fsm_states_0/and2_5/a_1_6# nh4 GND nfet w=6 l=2
+  ad=0 pd=0 as=42 ps=26
M1133 fsm_0/fsm_states_0/and2_5/a_1_6# fsm_0/fsm_states_0/_reset Vdd Vdd pfet w=12 l=2
+  ad=84 pd=38 as=0 ps=0
M1134 fsm_0/fsm_states_0/and2_5/a_14_9# fsm_0/fsm_states_0/_reset GND GND nfet w=6 l=2
+  ad=42 pd=26 as=0 ps=0
M1135 Vdd fsm_0/fsm_states_0/and2_5/a_1_6# nh4 Vdd pfet w=12 l=2
+  ad=0 pd=0 as=84 ps=38
M1136 Vdd h3 fsm_0/fsm_states_0/and2_5/a_1_6# Vdd pfet w=12 l=2
+  ad=0 pd=0 as=0 ps=0
M1137 fsm_0/fsm_states_0/and2_5/a_1_6# h3 fsm_0/fsm_states_0/and2_5/a_14_9# GND nfet w=6 l=2
+  ad=36 pd=24 as=0 ps=0
M1138 GND fsm_0/fsm_states_0/and2_6/a_1_6# nh5 GND nfet w=6 l=2
+  ad=0 pd=0 as=42 ps=26
M1139 fsm_0/fsm_states_0/and2_6/a_1_6# fsm_0/fsm_states_0/_reset Vdd Vdd pfet w=12 l=2
+  ad=84 pd=38 as=0 ps=0
M1140 fsm_0/fsm_states_0/and2_6/a_14_9# fsm_0/fsm_states_0/_reset GND GND nfet w=6 l=2
+  ad=42 pd=26 as=0 ps=0
M1141 Vdd fsm_0/fsm_states_0/and2_6/a_1_6# nh5 Vdd pfet w=12 l=2
+  ad=0 pd=0 as=84 ps=38
M1142 Vdd fsm_0/fsm_states_0/and2_6/B fsm_0/fsm_states_0/and2_6/a_1_6# Vdd pfet w=12 l=2
+  ad=0 pd=0 as=0 ps=0
M1143 fsm_0/fsm_states_0/and2_6/a_1_6# fsm_0/fsm_states_0/and2_6/B fsm_0/fsm_states_0/and2_6/a_14_9# GND nfet w=6 l=2
+  ad=36 pd=24 as=0 ps=0
M1144 GND PHI0 fsm_0/fsm_states_0/new_latch_1[0]/a_82_52# GND nfet w=5 l=2
+  ad=0 pd=0 as=30 ps=22
M1145 fsm_0/fsm_states_0/new_latch_1[0]/a_99_34# fsm_0/fsm_states_0/new_latch_1[0]/a_79_32# Vdd Vdd pfet w=10 l=2
+  ad=40 pd=28 as=0 ps=0
M1146 fsm_0/fsm_states_0/new_latch_1[0]/a_79_32# nh1 Vdd Vdd pfet w=10 l=2
+  ad=60 pd=32 as=0 ps=0
M1147 fsm_0/ih1 fsm_0/fsm_states_0/new_latch_1[0]/a_82_52# fsm_0/fsm_states_0/new_latch_1[0]/a_99_34# Vdd pfet w=10 l=2
+  ad=60 pd=32 as=0 ps=0
M1148 fsm_0/fsm_states_0/new_latch_1[0]/a_82_34# fsm_0/fsm_states_0/new_latch_1[0]/a_79_32# GND GND nfet w=5 l=2
+  ad=20 pd=18 as=0 ps=0
M1149 fsm_0/fsm_states_0/new_latch_1[0]/a_79_32# nh1 GND GND nfet w=5 l=2
+  ad=30 pd=22 as=0 ps=0
M1150 fsm_0/ih1 PHI0 fsm_0/fsm_states_0/new_latch_1[0]/a_82_34# GND nfet w=5 l=2
+  ad=30 pd=22 as=0 ps=0
M1151 Vdd PHI0 fsm_0/fsm_states_0/new_latch_1[0]/a_82_52# Vdd pfet w=10 l=2
+  ad=0 pd=0 as=60 ps=32
M1152 GND PHI0 fsm_0/fsm_states_0/new_latch_1[1]/a_82_52# GND nfet w=5 l=2
+  ad=0 pd=0 as=30 ps=22
M1153 fsm_0/fsm_states_0/new_latch_1[1]/a_99_34# fsm_0/fsm_states_0/new_latch_1[1]/a_79_32# Vdd Vdd pfet w=10 l=2
+  ad=40 pd=28 as=0 ps=0
M1154 fsm_0/fsm_states_0/new_latch_1[1]/a_79_32# nh2 Vdd Vdd pfet w=10 l=2
+  ad=60 pd=32 as=0 ps=0
M1155 fsm_0/ih2 fsm_0/fsm_states_0/new_latch_1[1]/a_82_52# fsm_0/fsm_states_0/new_latch_1[1]/a_99_34# Vdd pfet w=10 l=2
+  ad=60 pd=32 as=0 ps=0
M1156 fsm_0/fsm_states_0/new_latch_1[1]/a_82_34# fsm_0/fsm_states_0/new_latch_1[1]/a_79_32# GND GND nfet w=5 l=2
+  ad=20 pd=18 as=0 ps=0
M1157 fsm_0/fsm_states_0/new_latch_1[1]/a_79_32# nh2 GND GND nfet w=5 l=2
+  ad=30 pd=22 as=0 ps=0
M1158 fsm_0/ih2 PHI0 fsm_0/fsm_states_0/new_latch_1[1]/a_82_34# GND nfet w=5 l=2
+  ad=30 pd=22 as=0 ps=0
M1159 Vdd PHI0 fsm_0/fsm_states_0/new_latch_1[1]/a_82_52# Vdd pfet w=10 l=2
+  ad=0 pd=0 as=60 ps=32
M1160 GND PHI0 fsm_0/fsm_states_0/new_latch_1[2]/a_82_52# GND nfet w=5 l=2
+  ad=0 pd=0 as=30 ps=22
M1161 fsm_0/fsm_states_0/new_latch_1[2]/a_99_34# fsm_0/fsm_states_0/new_latch_1[2]/a_79_32# Vdd Vdd pfet w=10 l=2
+  ad=40 pd=28 as=0 ps=0
M1162 fsm_0/fsm_states_0/new_latch_1[2]/a_79_32# nh3 Vdd Vdd pfet w=10 l=2
+  ad=60 pd=32 as=0 ps=0
M1163 fsm_0/ih3 fsm_0/fsm_states_0/new_latch_1[2]/a_82_52# fsm_0/fsm_states_0/new_latch_1[2]/a_99_34# Vdd pfet w=10 l=2
+  ad=60 pd=32 as=0 ps=0
M1164 fsm_0/fsm_states_0/new_latch_1[2]/a_82_34# fsm_0/fsm_states_0/new_latch_1[2]/a_79_32# GND GND nfet w=5 l=2
+  ad=20 pd=18 as=0 ps=0
M1165 fsm_0/fsm_states_0/new_latch_1[2]/a_79_32# nh3 GND GND nfet w=5 l=2
+  ad=30 pd=22 as=0 ps=0
M1166 fsm_0/ih3 PHI0 fsm_0/fsm_states_0/new_latch_1[2]/a_82_34# GND nfet w=5 l=2
+  ad=30 pd=22 as=0 ps=0
M1167 Vdd PHI0 fsm_0/fsm_states_0/new_latch_1[2]/a_82_52# Vdd pfet w=10 l=2
+  ad=0 pd=0 as=60 ps=32
M1168 GND PHI0 fsm_0/fsm_states_0/new_latch_1[3]/a_82_52# GND nfet w=5 l=2
+  ad=0 pd=0 as=30 ps=22
M1169 fsm_0/fsm_states_0/new_latch_1[3]/a_99_34# fsm_0/fsm_states_0/new_latch_1[3]/a_79_32# Vdd Vdd pfet w=10 l=2
+  ad=40 pd=28 as=0 ps=0
M1170 fsm_0/fsm_states_0/new_latch_1[3]/a_79_32# nh4 Vdd Vdd pfet w=10 l=2
+  ad=60 pd=32 as=0 ps=0
M1171 fsm_0/ih4 fsm_0/fsm_states_0/new_latch_1[3]/a_82_52# fsm_0/fsm_states_0/new_latch_1[3]/a_99_34# Vdd pfet w=10 l=2
+  ad=60 pd=32 as=0 ps=0
M1172 fsm_0/fsm_states_0/new_latch_1[3]/a_82_34# fsm_0/fsm_states_0/new_latch_1[3]/a_79_32# GND GND nfet w=5 l=2
+  ad=20 pd=18 as=0 ps=0
M1173 fsm_0/fsm_states_0/new_latch_1[3]/a_79_32# nh4 GND GND nfet w=5 l=2
+  ad=30 pd=22 as=0 ps=0
M1174 fsm_0/ih4 PHI0 fsm_0/fsm_states_0/new_latch_1[3]/a_82_34# GND nfet w=5 l=2
+  ad=30 pd=22 as=0 ps=0
M1175 Vdd PHI0 fsm_0/fsm_states_0/new_latch_1[3]/a_82_52# Vdd pfet w=10 l=2
+  ad=0 pd=0 as=60 ps=32
M1176 GND PHI0 fsm_0/fsm_states_0/new_latch_1[4]/a_82_52# GND nfet w=5 l=2
+  ad=0 pd=0 as=30 ps=22
M1177 fsm_0/fsm_states_0/new_latch_1[4]/a_99_34# fsm_0/fsm_states_0/new_latch_1[4]/a_79_32# Vdd Vdd pfet w=10 l=2
+  ad=40 pd=28 as=0 ps=0
M1178 fsm_0/fsm_states_0/new_latch_1[4]/a_79_32# nh5 Vdd Vdd pfet w=10 l=2
+  ad=60 pd=32 as=0 ps=0
M1179 fsm_0/ih5 fsm_0/fsm_states_0/new_latch_1[4]/a_82_52# fsm_0/fsm_states_0/new_latch_1[4]/a_99_34# Vdd pfet w=10 l=2
+  ad=60 pd=32 as=0 ps=0
M1180 fsm_0/fsm_states_0/new_latch_1[4]/a_82_34# fsm_0/fsm_states_0/new_latch_1[4]/a_79_32# GND GND nfet w=5 l=2
+  ad=20 pd=18 as=0 ps=0
M1181 fsm_0/fsm_states_0/new_latch_1[4]/a_79_32# nh5 GND GND nfet w=5 l=2
+  ad=30 pd=22 as=0 ps=0
M1182 fsm_0/ih5 PHI0 fsm_0/fsm_states_0/new_latch_1[4]/a_82_34# GND nfet w=5 l=2
+  ad=30 pd=22 as=0 ps=0
M1183 Vdd PHI0 fsm_0/fsm_states_0/new_latch_1[4]/a_82_52# Vdd pfet w=10 l=2
+  ad=0 pd=0 as=60 ps=32
M1184 GND PHI0 fsm_0/fsm_states_0/new_latch_1[5]/a_82_52# GND nfet w=5 l=2
+  ad=0 pd=0 as=30 ps=22
M1185 fsm_0/fsm_states_0/new_latch_1[5]/a_99_34# fsm_0/fsm_states_0/new_latch_1[5]/a_79_32# Vdd Vdd pfet w=10 l=2
+  ad=40 pd=28 as=0 ps=0
M1186 fsm_0/fsm_states_0/new_latch_1[5]/a_79_32# nh6 Vdd Vdd pfet w=10 l=2
+  ad=60 pd=32 as=0 ps=0
M1187 fsm_0/ih6 fsm_0/fsm_states_0/new_latch_1[5]/a_82_52# fsm_0/fsm_states_0/new_latch_1[5]/a_99_34# Vdd pfet w=10 l=2
+  ad=60 pd=32 as=0 ps=0
M1188 fsm_0/fsm_states_0/new_latch_1[5]/a_82_34# fsm_0/fsm_states_0/new_latch_1[5]/a_79_32# GND GND nfet w=5 l=2
+  ad=20 pd=18 as=0 ps=0
M1189 fsm_0/fsm_states_0/new_latch_1[5]/a_79_32# nh6 GND GND nfet w=5 l=2
+  ad=30 pd=22 as=0 ps=0
M1190 fsm_0/ih6 PHI0 fsm_0/fsm_states_0/new_latch_1[5]/a_82_34# GND nfet w=5 l=2
+  ad=30 pd=22 as=0 ps=0
M1191 Vdd PHI0 fsm_0/fsm_states_0/new_latch_1[5]/a_82_52# Vdd pfet w=10 l=2
+  ad=0 pd=0 as=60 ps=32
M1192 GND fsm_0/fsm_states_0/and2_7/a_1_6# nh6 GND nfet w=6 l=2
+  ad=0 pd=0 as=42 ps=26
M1193 fsm_0/fsm_states_0/and2_7/a_1_6# fsm_0/fsm_states_0/_reset Vdd Vdd pfet w=12 l=2
+  ad=84 pd=38 as=0 ps=0
M1194 fsm_0/fsm_states_0/and2_7/a_14_9# fsm_0/fsm_states_0/_reset GND GND nfet w=6 l=2
+  ad=42 pd=26 as=0 ps=0
M1195 Vdd fsm_0/fsm_states_0/and2_7/a_1_6# nh6 Vdd pfet w=12 l=2
+  ad=0 pd=0 as=84 ps=38
M1196 Vdd h5 fsm_0/fsm_states_0/and2_7/a_1_6# Vdd pfet w=12 l=2
+  ad=0 pd=0 as=0 ps=0
M1197 fsm_0/fsm_states_0/and2_7/a_1_6# h5 fsm_0/fsm_states_0/and2_7/a_14_9# GND nfet w=6 l=2
+  ad=36 pd=24 as=0 ps=0
M1198 GND fsm_0/fsm_states_0/and2_8/a_1_6# fsm_0/fsm_states_0/and2_6/B GND nfet w=6 l=2
+  ad=0 pd=0 as=42 ps=26
M1199 fsm_0/fsm_states_0/and2_8/a_1_6# ITER Vdd Vdd pfet w=12 l=2
+  ad=84 pd=38 as=0 ps=0
M1200 fsm_0/fsm_states_0/and2_8/a_14_9# ITER GND GND nfet w=6 l=2
+  ad=42 pd=26 as=0 ps=0
M1201 Vdd fsm_0/fsm_states_0/and2_8/a_1_6# fsm_0/fsm_states_0/and2_6/B Vdd pfet w=12 l=2
+  ad=0 pd=0 as=84 ps=38
M1202 Vdd h1 fsm_0/fsm_states_0/and2_8/a_1_6# Vdd pfet w=12 l=2
+  ad=0 pd=0 as=0 ps=0
M1203 fsm_0/fsm_states_0/and2_8/a_1_6# h1 fsm_0/fsm_states_0/and2_8/a_14_9# GND nfet w=6 l=2
+  ad=36 pd=24 as=0 ps=0
M1204 fsm_0/or2_0/a_2_9# h3 GND GND nfet w=6 l=2
+  ad=42 pd=26 as=0 ps=0
M1205 fsm_0/or2_0/a_2_9# h2 fsm_0/or2_0/a_15_37# Vdd pfet w=12 l=2
+  ad=72 pd=36 as=84 ps=38
M1206 GND fsm_0/or2_0/a_2_9# fsm_0/and2_0/B GND nfet w=6 l=2
+  ad=0 pd=0 as=42 ps=26
M1207 fsm_0/or2_0/a_15_37# h3 Vdd Vdd pfet w=12 l=2
+  ad=0 pd=0 as=0 ps=0
M1208 GND h2 fsm_0/or2_0/a_2_9# GND nfet w=6 l=2
+  ad=0 pd=0 as=0 ps=0
M1209 Vdd fsm_0/or2_0/a_2_9# fsm_0/and2_0/B Vdd pfet w=12 l=2
+  ad=0 pd=0 as=84 ps=38
M1210 fsm_0/or2_1/a_2_9# fsm_0/rd GND GND nfet w=6 l=2
+  ad=42 pd=26 as=0 ps=0
M1211 fsm_0/or2_1/a_2_9# fsm_0/reg0r0phi1 fsm_0/or2_1/a_15_37# Vdd pfet w=12 l=2
+  ad=72 pd=36 as=84 ps=38
M1212 GND fsm_0/or2_1/a_2_9# fsm_0/reg0r0 GND nfet w=6 l=2
+  ad=0 pd=0 as=42 ps=26
M1213 fsm_0/or2_1/a_15_37# fsm_0/rd Vdd Vdd pfet w=12 l=2
+  ad=0 pd=0 as=0 ps=0
M1214 GND fsm_0/reg0r0phi1 fsm_0/or2_1/a_2_9# GND nfet w=6 l=2
+  ad=0 pd=0 as=0 ps=0
M1215 Vdd fsm_0/or2_1/a_2_9# fsm_0/reg0r0 Vdd pfet w=12 l=2
+  ad=0 pd=0 as=84 ps=38
M1216 fsm_0/and2_1/A fsm_0/inv_0/in GND GND nfet w=5 l=2
+  ad=30 pd=22 as=0 ps=0
M1217 fsm_0/and2_1/A fsm_0/inv_0/in Vdd Vdd pfet w=10 l=2
+  ad=60 pd=32 as=0 ps=0
M1218 GND fsm_0/and2_modified_0/a_1_6# fsm_0/rfb GND nfet w=6 l=2
+  ad=0 pd=0 as=42 ps=26
M1219 fsm_0/and2_modified_0/a_1_6# fsm_0/or4_0/out Vdd Vdd pfet w=12 l=2
+  ad=84 pd=38 as=0 ps=0
M1220 fsm_0/and2_modified_0/a_14_9# fsm_0/or4_0/out GND GND nfet w=6 l=2
+  ad=42 pd=26 as=0 ps=0
M1221 Vdd fsm_0/and2_modified_0/a_1_6# fsm_0/rfb Vdd pfet w=12 l=2
+  ad=0 pd=0 as=84 ps=38
M1222 Vdd PHI1 fsm_0/and2_modified_0/a_1_6# Vdd pfet w=12 l=2
+  ad=0 pd=0 as=0 ps=0
M1223 fsm_0/and2_modified_0/a_1_6# PHI1 fsm_0/and2_modified_0/a_14_9# GND nfet w=6 l=2
+  ad=36 pd=24 as=0 ps=0
M1224 GND fsm_0/and2_0/a_1_6# fsm_0/reg1w GND nfet w=6 l=2
+  ad=0 pd=0 as=42 ps=26
M1225 fsm_0/and2_0/a_1_6# PHI0 Vdd Vdd pfet w=12 l=2
+  ad=84 pd=38 as=0 ps=0
M1226 fsm_0/and2_0/a_14_9# PHI0 GND GND nfet w=6 l=2
+  ad=42 pd=26 as=0 ps=0
M1227 Vdd fsm_0/and2_0/a_1_6# fsm_0/reg1w Vdd pfet w=12 l=2
+  ad=0 pd=0 as=84 ps=38
M1228 Vdd fsm_0/and2_0/B fsm_0/and2_0/a_1_6# Vdd pfet w=12 l=2
+  ad=0 pd=0 as=0 ps=0
M1229 fsm_0/and2_0/a_1_6# fsm_0/and2_0/B fsm_0/and2_0/a_14_9# GND nfet w=6 l=2
+  ad=36 pd=24 as=0 ps=0
M1230 GND fsm_0/and2_1/a_1_6# fsm_0/reg0r0phi1 GND nfet w=6 l=2
+  ad=0 pd=0 as=42 ps=26
M1231 fsm_0/and2_1/a_1_6# fsm_0/and2_1/A Vdd Vdd pfet w=12 l=2
+  ad=84 pd=38 as=0 ps=0
M1232 fsm_0/and2_1/a_14_9# fsm_0/and2_1/A GND GND nfet w=6 l=2
+  ad=42 pd=26 as=0 ps=0
M1233 Vdd fsm_0/and2_1/a_1_6# fsm_0/reg0r0phi1 Vdd pfet w=12 l=2
+  ad=0 pd=0 as=84 ps=38
M1234 Vdd fsm_0/and2_1/B fsm_0/and2_1/a_1_6# Vdd pfet w=12 l=2
+  ad=0 pd=0 as=0 ps=0
M1235 fsm_0/and2_1/a_1_6# fsm_0/and2_1/B fsm_0/and2_1/a_14_9# GND nfet w=6 l=2
+  ad=36 pd=24 as=0 ps=0
M1236 GND fsm_0/and2_2/a_1_6# fsm_0/reg0w GND nfet w=6 l=2
+  ad=0 pd=0 as=42 ps=26
M1237 fsm_0/and2_2/a_1_6# PHI0 Vdd Vdd pfet w=12 l=2
+  ad=84 pd=38 as=0 ps=0
M1238 fsm_0/and2_2/a_14_9# PHI0 GND GND nfet w=6 l=2
+  ad=42 pd=26 as=0 ps=0
M1239 Vdd fsm_0/and2_2/a_1_6# fsm_0/reg0w Vdd pfet w=12 l=2
+  ad=0 pd=0 as=84 ps=38
M1240 Vdd fsm_0/and2_2/B fsm_0/and2_2/a_1_6# Vdd pfet w=12 l=2
+  ad=0 pd=0 as=0 ps=0
M1241 fsm_0/and2_2/a_1_6# fsm_0/and2_2/B fsm_0/and2_2/a_14_9# GND nfet w=6 l=2
+  ad=36 pd=24 as=0 ps=0
M1242 GND fsm_0/and2_3/a_1_6# fsm_0/ld GND nfet w=6 l=2
+  ad=0 pd=0 as=42 ps=26
M1243 fsm_0/and2_3/a_1_6# PHI1 Vdd Vdd pfet w=12 l=2
+  ad=84 pd=38 as=0 ps=0
M1244 fsm_0/and2_3/a_14_9# PHI1 GND GND nfet w=6 l=2
+  ad=42 pd=26 as=0 ps=0
M1245 Vdd fsm_0/and2_3/a_1_6# fsm_0/ld Vdd pfet w=12 l=2
+  ad=0 pd=0 as=84 ps=38
M1246 Vdd h3 fsm_0/and2_3/a_1_6# Vdd pfet w=12 l=2
+  ad=0 pd=0 as=0 ps=0
M1247 fsm_0/and2_3/a_1_6# h3 fsm_0/and2_3/a_14_9# GND nfet w=6 l=2
+  ad=36 pd=24 as=0 ps=0
M1248 GND fsm_0/m1_568_227# fsm_0/reg1r1 GND nfet w=6 l=2
+  ad=0 pd=0 as=42 ps=26
M1249 fsm_0/m1_568_227# PHI1 Vdd Vdd pfet w=12 l=2
+  ad=84 pd=38 as=0 ps=0
M1250 fsm_0/and2_4/a_14_9# PHI1 GND GND nfet w=6 l=2
+  ad=42 pd=26 as=0 ps=0
M1251 Vdd fsm_0/m1_568_227# fsm_0/reg1r1 Vdd pfet w=12 l=2
+  ad=0 pd=0 as=84 ps=38
M1252 Vdd h6 fsm_0/m1_568_227# Vdd pfet w=12 l=2
+  ad=0 pd=0 as=0 ps=0
M1253 fsm_0/m1_568_227# h6 fsm_0/and2_4/a_14_9# GND nfet w=6 l=2
+  ad=36 pd=24 as=0 ps=0
M1254 GND fsm_0/and2_5/a_1_6# datapath_0/g2 GND nfet w=6 l=2
+  ad=0 pd=0 as=42 ps=26
M1255 fsm_0/and2_5/a_1_6# PHI1 Vdd Vdd pfet w=12 l=2
+  ad=84 pd=38 as=0 ps=0
M1256 fsm_0/and2_5/a_14_9# PHI1 GND GND nfet w=6 l=2
+  ad=42 pd=26 as=0 ps=0
M1257 Vdd fsm_0/and2_5/a_1_6# datapath_0/g2 Vdd pfet w=12 l=2
+  ad=0 pd=0 as=84 ps=38
M1258 Vdd h6 fsm_0/and2_5/a_1_6# Vdd pfet w=12 l=2
+  ad=0 pd=0 as=0 ps=0
M1259 fsm_0/and2_5/a_1_6# h6 fsm_0/and2_5/a_14_9# GND nfet w=6 l=2
+  ad=36 pd=24 as=0 ps=0
M1260 GND fsm_0/and2_6/a_1_6# fsm_0/ros GND nfet w=6 l=2
+  ad=0 pd=0 as=42 ps=26
M1261 fsm_0/and2_6/a_1_6# h5 Vdd Vdd pfet w=12 l=2
+  ad=84 pd=38 as=0 ps=0
M1262 fsm_0/and2_6/a_14_9# h5 GND GND nfet w=6 l=2
+  ad=42 pd=26 as=0 ps=0
M1263 Vdd fsm_0/and2_6/a_1_6# fsm_0/ros Vdd pfet w=12 l=2
+  ad=0 pd=0 as=84 ps=38
M1264 Vdd fsm_0/and2_6/B fsm_0/and2_6/a_1_6# Vdd pfet w=12 l=2
+  ad=0 pd=0 as=0 ps=0
M1265 fsm_0/and2_6/a_1_6# fsm_0/and2_6/B fsm_0/and2_6/a_14_9# GND nfet w=6 l=2
+  ad=36 pd=24 as=0 ps=0
M1266 datapath_0/staticizer_1/staticizer_one_0[0]/inv_0/out datapath_0/staticizer_1/staticizer_one_0[0]/internal GND GND nfet w=5 l=2
+  ad=60 pd=44 as=0 ps=0
M1267 datapath_0/staticizer_1/staticizer_one_0[0]/inv_0/out datapath_0/staticizer_1/staticizer_one_0[0]/internal Vdd Vdd pfet w=10 l=2
+  ad=120 pd=64 as=0 ps=0
M1268 datapath_0/staticizer_1/staticizer_one_0[0]/internal datapath_0/wz0 GND GND nfet w=5 l=2
+  ad=30 pd=22 as=0 ps=0
M1269 datapath_0/staticizer_1/staticizer_one_0[0]/internal datapath_0/wz0 Vdd Vdd pfet w=10 l=2
+  ad=60 pd=32 as=0 ps=0
M1270 datapath_0/staticizer_1/staticizer_one_0[0]/inv_2/out datapath_0/or4_0/out GND GND nfet w=5 l=2
+  ad=30 pd=22 as=0 ps=0
M1271 datapath_0/staticizer_1/staticizer_one_0[0]/inv_2/out datapath_0/or4_0/out Vdd Vdd pfet w=10 l=2
+  ad=60 pd=32 as=0 ps=0
M1272 GND datapath_0/staticizer_1/staticizer_one_0[0]/inv_2/out datapath_0/staticizer_1/staticizer_one_0[0]/new_latch_0/a_82_52# GND nfet w=5 l=2
+  ad=0 pd=0 as=30 ps=22
M1273 datapath_0/staticizer_1/staticizer_one_0[0]/new_latch_0/a_99_34# datapath_0/staticizer_1/staticizer_one_0[0]/new_latch_0/a_79_32# Vdd Vdd pfet w=10 l=2
+  ad=40 pd=28 as=0 ps=0
M1274 datapath_0/staticizer_1/staticizer_one_0[0]/new_latch_0/a_79_32# datapath_0/wz0 Vdd Vdd pfet w=10 l=2
+  ad=60 pd=32 as=0 ps=0
M1275 datapath_0/staticizer_1/staticizer_one_0[0]/inv_0/out datapath_0/staticizer_1/staticizer_one_0[0]/new_latch_0/a_82_52# datapath_0/staticizer_1/staticizer_one_0[0]/new_latch_0/a_99_34# Vdd pfet w=10 l=2
+  ad=0 pd=0 as=0 ps=0
M1276 datapath_0/staticizer_1/staticizer_one_0[0]/new_latch_0/a_82_34# datapath_0/staticizer_1/staticizer_one_0[0]/new_latch_0/a_79_32# GND GND nfet w=5 l=2
+  ad=20 pd=18 as=0 ps=0
M1277 datapath_0/staticizer_1/staticizer_one_0[0]/new_latch_0/a_79_32# datapath_0/wz0 GND GND nfet w=5 l=2
+  ad=30 pd=22 as=0 ps=0
M1278 datapath_0/staticizer_1/staticizer_one_0[0]/inv_0/out datapath_0/staticizer_1/staticizer_one_0[0]/inv_2/out datapath_0/staticizer_1/staticizer_one_0[0]/new_latch_0/a_82_34# GND nfet w=5 l=2
+  ad=0 pd=0 as=0 ps=0
M1279 Vdd datapath_0/staticizer_1/staticizer_one_0[0]/inv_2/out datapath_0/staticizer_1/staticizer_one_0[0]/new_latch_0/a_82_52# Vdd pfet w=10 l=2
+  ad=0 pd=0 as=60 ps=32
M1280 datapath_0/staticizer_1/staticizer_one_0[1]/inv_0/out datapath_0/staticizer_1/staticizer_one_0[1]/internal GND GND nfet w=5 l=2
+  ad=60 pd=44 as=0 ps=0
M1281 datapath_0/staticizer_1/staticizer_one_0[1]/inv_0/out datapath_0/staticizer_1/staticizer_one_0[1]/internal Vdd Vdd pfet w=10 l=2
+  ad=120 pd=64 as=0 ps=0
M1282 datapath_0/staticizer_1/staticizer_one_0[1]/internal datapath_0/wz1 GND GND nfet w=5 l=2
+  ad=30 pd=22 as=0 ps=0
M1283 datapath_0/staticizer_1/staticizer_one_0[1]/internal datapath_0/wz1 Vdd Vdd pfet w=10 l=2
+  ad=60 pd=32 as=0 ps=0
M1284 datapath_0/staticizer_1/staticizer_one_0[1]/inv_2/out datapath_0/or4_0/out GND GND nfet w=5 l=2
+  ad=30 pd=22 as=0 ps=0
M1285 datapath_0/staticizer_1/staticizer_one_0[1]/inv_2/out datapath_0/or4_0/out Vdd Vdd pfet w=10 l=2
+  ad=60 pd=32 as=0 ps=0
M1286 GND datapath_0/staticizer_1/staticizer_one_0[1]/inv_2/out datapath_0/staticizer_1/staticizer_one_0[1]/new_latch_0/a_82_52# GND nfet w=5 l=2
+  ad=0 pd=0 as=30 ps=22
M1287 datapath_0/staticizer_1/staticizer_one_0[1]/new_latch_0/a_99_34# datapath_0/staticizer_1/staticizer_one_0[1]/new_latch_0/a_79_32# Vdd Vdd pfet w=10 l=2
+  ad=40 pd=28 as=0 ps=0
M1288 datapath_0/staticizer_1/staticizer_one_0[1]/new_latch_0/a_79_32# datapath_0/wz1 Vdd Vdd pfet w=10 l=2
+  ad=60 pd=32 as=0 ps=0
M1289 datapath_0/staticizer_1/staticizer_one_0[1]/inv_0/out datapath_0/staticizer_1/staticizer_one_0[1]/new_latch_0/a_82_52# datapath_0/staticizer_1/staticizer_one_0[1]/new_latch_0/a_99_34# Vdd pfet w=10 l=2
+  ad=0 pd=0 as=0 ps=0
M1290 datapath_0/staticizer_1/staticizer_one_0[1]/new_latch_0/a_82_34# datapath_0/staticizer_1/staticizer_one_0[1]/new_latch_0/a_79_32# GND GND nfet w=5 l=2
+  ad=20 pd=18 as=0 ps=0
M1291 datapath_0/staticizer_1/staticizer_one_0[1]/new_latch_0/a_79_32# datapath_0/wz1 GND GND nfet w=5 l=2
+  ad=30 pd=22 as=0 ps=0
M1292 datapath_0/staticizer_1/staticizer_one_0[1]/inv_0/out datapath_0/staticizer_1/staticizer_one_0[1]/inv_2/out datapath_0/staticizer_1/staticizer_one_0[1]/new_latch_0/a_82_34# GND nfet w=5 l=2
+  ad=0 pd=0 as=0 ps=0
M1293 Vdd datapath_0/staticizer_1/staticizer_one_0[1]/inv_2/out datapath_0/staticizer_1/staticizer_one_0[1]/new_latch_0/a_82_52# Vdd pfet w=10 l=2
+  ad=0 pd=0 as=60 ps=32
M1294 datapath_0/staticizer_1/staticizer_one_0[2]/inv_0/out datapath_0/staticizer_1/staticizer_one_0[2]/internal GND GND nfet w=5 l=2
+  ad=60 pd=44 as=0 ps=0
M1295 datapath_0/staticizer_1/staticizer_one_0[2]/inv_0/out datapath_0/staticizer_1/staticizer_one_0[2]/internal Vdd Vdd pfet w=10 l=2
+  ad=120 pd=64 as=0 ps=0
M1296 datapath_0/staticizer_1/staticizer_one_0[2]/internal datapath_0/wz2 GND GND nfet w=5 l=2
+  ad=30 pd=22 as=0 ps=0
M1297 datapath_0/staticizer_1/staticizer_one_0[2]/internal datapath_0/wz2 Vdd Vdd pfet w=10 l=2
+  ad=60 pd=32 as=0 ps=0
M1298 datapath_0/staticizer_1/staticizer_one_0[2]/inv_2/out datapath_0/or4_0/out GND GND nfet w=5 l=2
+  ad=30 pd=22 as=0 ps=0
M1299 datapath_0/staticizer_1/staticizer_one_0[2]/inv_2/out datapath_0/or4_0/out Vdd Vdd pfet w=10 l=2
+  ad=60 pd=32 as=0 ps=0
M1300 GND datapath_0/staticizer_1/staticizer_one_0[2]/inv_2/out datapath_0/staticizer_1/staticizer_one_0[2]/new_latch_0/a_82_52# GND nfet w=5 l=2
+  ad=0 pd=0 as=30 ps=22
M1301 datapath_0/staticizer_1/staticizer_one_0[2]/new_latch_0/a_99_34# datapath_0/staticizer_1/staticizer_one_0[2]/new_latch_0/a_79_32# Vdd Vdd pfet w=10 l=2
+  ad=40 pd=28 as=0 ps=0
M1302 datapath_0/staticizer_1/staticizer_one_0[2]/new_latch_0/a_79_32# datapath_0/wz2 Vdd Vdd pfet w=10 l=2
+  ad=60 pd=32 as=0 ps=0
M1303 datapath_0/staticizer_1/staticizer_one_0[2]/inv_0/out datapath_0/staticizer_1/staticizer_one_0[2]/new_latch_0/a_82_52# datapath_0/staticizer_1/staticizer_one_0[2]/new_latch_0/a_99_34# Vdd pfet w=10 l=2
+  ad=0 pd=0 as=0 ps=0
M1304 datapath_0/staticizer_1/staticizer_one_0[2]/new_latch_0/a_82_34# datapath_0/staticizer_1/staticizer_one_0[2]/new_latch_0/a_79_32# GND GND nfet w=5 l=2
+  ad=20 pd=18 as=0 ps=0
M1305 datapath_0/staticizer_1/staticizer_one_0[2]/new_latch_0/a_79_32# datapath_0/wz2 GND GND nfet w=5 l=2
+  ad=30 pd=22 as=0 ps=0
M1306 datapath_0/staticizer_1/staticizer_one_0[2]/inv_0/out datapath_0/staticizer_1/staticizer_one_0[2]/inv_2/out datapath_0/staticizer_1/staticizer_one_0[2]/new_latch_0/a_82_34# GND nfet w=5 l=2
+  ad=0 pd=0 as=0 ps=0
M1307 Vdd datapath_0/staticizer_1/staticizer_one_0[2]/inv_2/out datapath_0/staticizer_1/staticizer_one_0[2]/new_latch_0/a_82_52# Vdd pfet w=10 l=2
+  ad=0 pd=0 as=60 ps=32
M1308 datapath_0/staticizer_1/staticizer_one_0[3]/inv_0/out datapath_0/staticizer_1/staticizer_one_0[3]/internal GND GND nfet w=5 l=2
+  ad=60 pd=44 as=0 ps=0
M1309 datapath_0/staticizer_1/staticizer_one_0[3]/inv_0/out datapath_0/staticizer_1/staticizer_one_0[3]/internal Vdd Vdd pfet w=10 l=2
+  ad=120 pd=64 as=0 ps=0
M1310 datapath_0/staticizer_1/staticizer_one_0[3]/internal datapath_0/wz3 GND GND nfet w=5 l=2
+  ad=30 pd=22 as=0 ps=0
M1311 datapath_0/staticizer_1/staticizer_one_0[3]/internal datapath_0/wz3 Vdd Vdd pfet w=10 l=2
+  ad=60 pd=32 as=0 ps=0
M1312 datapath_0/staticizer_1/staticizer_one_0[3]/inv_2/out datapath_0/or4_0/out GND GND nfet w=5 l=2
+  ad=30 pd=22 as=0 ps=0
M1313 datapath_0/staticizer_1/staticizer_one_0[3]/inv_2/out datapath_0/or4_0/out Vdd Vdd pfet w=10 l=2
+  ad=60 pd=32 as=0 ps=0
M1314 GND datapath_0/staticizer_1/staticizer_one_0[3]/inv_2/out datapath_0/staticizer_1/staticizer_one_0[3]/new_latch_0/a_82_52# GND nfet w=5 l=2
+  ad=0 pd=0 as=30 ps=22
M1315 datapath_0/staticizer_1/staticizer_one_0[3]/new_latch_0/a_99_34# datapath_0/staticizer_1/staticizer_one_0[3]/new_latch_0/a_79_32# Vdd Vdd pfet w=10 l=2
+  ad=40 pd=28 as=0 ps=0
M1316 datapath_0/staticizer_1/staticizer_one_0[3]/new_latch_0/a_79_32# datapath_0/wz3 Vdd Vdd pfet w=10 l=2
+  ad=60 pd=32 as=0 ps=0
M1317 datapath_0/staticizer_1/staticizer_one_0[3]/inv_0/out datapath_0/staticizer_1/staticizer_one_0[3]/new_latch_0/a_82_52# datapath_0/staticizer_1/staticizer_one_0[3]/new_latch_0/a_99_34# Vdd pfet w=10 l=2
+  ad=0 pd=0 as=0 ps=0
M1318 datapath_0/staticizer_1/staticizer_one_0[3]/new_latch_0/a_82_34# datapath_0/staticizer_1/staticizer_one_0[3]/new_latch_0/a_79_32# GND GND nfet w=5 l=2
+  ad=20 pd=18 as=0 ps=0
M1319 datapath_0/staticizer_1/staticizer_one_0[3]/new_latch_0/a_79_32# datapath_0/wz3 GND GND nfet w=5 l=2
+  ad=30 pd=22 as=0 ps=0
M1320 datapath_0/staticizer_1/staticizer_one_0[3]/inv_0/out datapath_0/staticizer_1/staticizer_one_0[3]/inv_2/out datapath_0/staticizer_1/staticizer_one_0[3]/new_latch_0/a_82_34# GND nfet w=5 l=2
+  ad=0 pd=0 as=0 ps=0
M1321 Vdd datapath_0/staticizer_1/staticizer_one_0[3]/inv_2/out datapath_0/staticizer_1/staticizer_one_0[3]/new_latch_0/a_82_52# Vdd pfet w=10 l=2
+  ad=0 pd=0 as=60 ps=32
M1322 datapath_0/staticizer_1/staticizer_one_0[4]/inv_0/out datapath_0/staticizer_1/staticizer_one_0[4]/internal GND GND nfet w=5 l=2
+  ad=60 pd=44 as=0 ps=0
M1323 datapath_0/staticizer_1/staticizer_one_0[4]/inv_0/out datapath_0/staticizer_1/staticizer_one_0[4]/internal Vdd Vdd pfet w=10 l=2
+  ad=120 pd=64 as=0 ps=0
M1324 datapath_0/staticizer_1/staticizer_one_0[4]/internal datapath_0/wz4 GND GND nfet w=5 l=2
+  ad=30 pd=22 as=0 ps=0
M1325 datapath_0/staticizer_1/staticizer_one_0[4]/internal datapath_0/wz4 Vdd Vdd pfet w=10 l=2
+  ad=60 pd=32 as=0 ps=0
M1326 datapath_0/staticizer_1/staticizer_one_0[4]/inv_2/out datapath_0/or4_0/out GND GND nfet w=5 l=2
+  ad=30 pd=22 as=0 ps=0
M1327 datapath_0/staticizer_1/staticizer_one_0[4]/inv_2/out datapath_0/or4_0/out Vdd Vdd pfet w=10 l=2
+  ad=60 pd=32 as=0 ps=0
M1328 GND datapath_0/staticizer_1/staticizer_one_0[4]/inv_2/out datapath_0/staticizer_1/staticizer_one_0[4]/new_latch_0/a_82_52# GND nfet w=5 l=2
+  ad=0 pd=0 as=30 ps=22
M1329 datapath_0/staticizer_1/staticizer_one_0[4]/new_latch_0/a_99_34# datapath_0/staticizer_1/staticizer_one_0[4]/new_latch_0/a_79_32# Vdd Vdd pfet w=10 l=2
+  ad=40 pd=28 as=0 ps=0
M1330 datapath_0/staticizer_1/staticizer_one_0[4]/new_latch_0/a_79_32# datapath_0/wz4 Vdd Vdd pfet w=10 l=2
+  ad=60 pd=32 as=0 ps=0
M1331 datapath_0/staticizer_1/staticizer_one_0[4]/inv_0/out datapath_0/staticizer_1/staticizer_one_0[4]/new_latch_0/a_82_52# datapath_0/staticizer_1/staticizer_one_0[4]/new_latch_0/a_99_34# Vdd pfet w=10 l=2
+  ad=0 pd=0 as=0 ps=0
M1332 datapath_0/staticizer_1/staticizer_one_0[4]/new_latch_0/a_82_34# datapath_0/staticizer_1/staticizer_one_0[4]/new_latch_0/a_79_32# GND GND nfet w=5 l=2
+  ad=20 pd=18 as=0 ps=0
M1333 datapath_0/staticizer_1/staticizer_one_0[4]/new_latch_0/a_79_32# datapath_0/wz4 GND GND nfet w=5 l=2
+  ad=30 pd=22 as=0 ps=0
M1334 datapath_0/staticizer_1/staticizer_one_0[4]/inv_0/out datapath_0/staticizer_1/staticizer_one_0[4]/inv_2/out datapath_0/staticizer_1/staticizer_one_0[4]/new_latch_0/a_82_34# GND nfet w=5 l=2
+  ad=0 pd=0 as=0 ps=0
M1335 Vdd datapath_0/staticizer_1/staticizer_one_0[4]/inv_2/out datapath_0/staticizer_1/staticizer_one_0[4]/new_latch_0/a_82_52# Vdd pfet w=10 l=2
+  ad=0 pd=0 as=60 ps=32
M1336 datapath_0/staticizer_1/staticizer_one_0[5]/inv_0/out datapath_0/staticizer_1/staticizer_one_0[5]/internal GND GND nfet w=5 l=2
+  ad=60 pd=44 as=0 ps=0
M1337 datapath_0/staticizer_1/staticizer_one_0[5]/inv_0/out datapath_0/staticizer_1/staticizer_one_0[5]/internal Vdd Vdd pfet w=10 l=2
+  ad=120 pd=64 as=0 ps=0
M1338 datapath_0/staticizer_1/staticizer_one_0[5]/internal datapath_0/wz5 GND GND nfet w=5 l=2
+  ad=30 pd=22 as=0 ps=0
M1339 datapath_0/staticizer_1/staticizer_one_0[5]/internal datapath_0/wz5 Vdd Vdd pfet w=10 l=2
+  ad=60 pd=32 as=0 ps=0
M1340 datapath_0/staticizer_1/staticizer_one_0[5]/inv_2/out datapath_0/or4_0/out GND GND nfet w=5 l=2
+  ad=30 pd=22 as=0 ps=0
M1341 datapath_0/staticizer_1/staticizer_one_0[5]/inv_2/out datapath_0/or4_0/out Vdd Vdd pfet w=10 l=2
+  ad=60 pd=32 as=0 ps=0
M1342 GND datapath_0/staticizer_1/staticizer_one_0[5]/inv_2/out datapath_0/staticizer_1/staticizer_one_0[5]/new_latch_0/a_82_52# GND nfet w=5 l=2
+  ad=0 pd=0 as=30 ps=22
M1343 datapath_0/staticizer_1/staticizer_one_0[5]/new_latch_0/a_99_34# datapath_0/staticizer_1/staticizer_one_0[5]/new_latch_0/a_79_32# Vdd Vdd pfet w=10 l=2
+  ad=40 pd=28 as=0 ps=0
M1344 datapath_0/staticizer_1/staticizer_one_0[5]/new_latch_0/a_79_32# datapath_0/wz5 Vdd Vdd pfet w=10 l=2
+  ad=60 pd=32 as=0 ps=0
M1345 datapath_0/staticizer_1/staticizer_one_0[5]/inv_0/out datapath_0/staticizer_1/staticizer_one_0[5]/new_latch_0/a_82_52# datapath_0/staticizer_1/staticizer_one_0[5]/new_latch_0/a_99_34# Vdd pfet w=10 l=2
+  ad=0 pd=0 as=0 ps=0
M1346 datapath_0/staticizer_1/staticizer_one_0[5]/new_latch_0/a_82_34# datapath_0/staticizer_1/staticizer_one_0[5]/new_latch_0/a_79_32# GND GND nfet w=5 l=2
+  ad=20 pd=18 as=0 ps=0
M1347 datapath_0/staticizer_1/staticizer_one_0[5]/new_latch_0/a_79_32# datapath_0/wz5 GND GND nfet w=5 l=2
+  ad=30 pd=22 as=0 ps=0
M1348 datapath_0/staticizer_1/staticizer_one_0[5]/inv_0/out datapath_0/staticizer_1/staticizer_one_0[5]/inv_2/out datapath_0/staticizer_1/staticizer_one_0[5]/new_latch_0/a_82_34# GND nfet w=5 l=2
+  ad=0 pd=0 as=0 ps=0
M1349 Vdd datapath_0/staticizer_1/staticizer_one_0[5]/inv_2/out datapath_0/staticizer_1/staticizer_one_0[5]/new_latch_0/a_82_52# Vdd pfet w=10 l=2
+  ad=0 pd=0 as=60 ps=32
M1350 datapath_0/staticizer_1/staticizer_one_0[6]/inv_0/out datapath_0/staticizer_1/staticizer_one_0[6]/internal GND GND nfet w=5 l=2
+  ad=60 pd=44 as=0 ps=0
M1351 datapath_0/staticizer_1/staticizer_one_0[6]/inv_0/out datapath_0/staticizer_1/staticizer_one_0[6]/internal Vdd Vdd pfet w=10 l=2
+  ad=120 pd=64 as=0 ps=0
M1352 datapath_0/staticizer_1/staticizer_one_0[6]/internal datapath_0/wz6 GND GND nfet w=5 l=2
+  ad=30 pd=22 as=0 ps=0
M1353 datapath_0/staticizer_1/staticizer_one_0[6]/internal datapath_0/wz6 Vdd Vdd pfet w=10 l=2
+  ad=60 pd=32 as=0 ps=0
M1354 datapath_0/staticizer_1/staticizer_one_0[6]/inv_2/out datapath_0/or4_0/out GND GND nfet w=5 l=2
+  ad=30 pd=22 as=0 ps=0
M1355 datapath_0/staticizer_1/staticizer_one_0[6]/inv_2/out datapath_0/or4_0/out Vdd Vdd pfet w=10 l=2
+  ad=60 pd=32 as=0 ps=0
M1356 GND datapath_0/staticizer_1/staticizer_one_0[6]/inv_2/out datapath_0/staticizer_1/staticizer_one_0[6]/new_latch_0/a_82_52# GND nfet w=5 l=2
+  ad=0 pd=0 as=30 ps=22
M1357 datapath_0/staticizer_1/staticizer_one_0[6]/new_latch_0/a_99_34# datapath_0/staticizer_1/staticizer_one_0[6]/new_latch_0/a_79_32# Vdd Vdd pfet w=10 l=2
+  ad=40 pd=28 as=0 ps=0
M1358 datapath_0/staticizer_1/staticizer_one_0[6]/new_latch_0/a_79_32# datapath_0/wz6 Vdd Vdd pfet w=10 l=2
+  ad=60 pd=32 as=0 ps=0
M1359 datapath_0/staticizer_1/staticizer_one_0[6]/inv_0/out datapath_0/staticizer_1/staticizer_one_0[6]/new_latch_0/a_82_52# datapath_0/staticizer_1/staticizer_one_0[6]/new_latch_0/a_99_34# Vdd pfet w=10 l=2
+  ad=0 pd=0 as=0 ps=0
M1360 datapath_0/staticizer_1/staticizer_one_0[6]/new_latch_0/a_82_34# datapath_0/staticizer_1/staticizer_one_0[6]/new_latch_0/a_79_32# GND GND nfet w=5 l=2
+  ad=20 pd=18 as=0 ps=0
M1361 datapath_0/staticizer_1/staticizer_one_0[6]/new_latch_0/a_79_32# datapath_0/wz6 GND GND nfet w=5 l=2
+  ad=30 pd=22 as=0 ps=0
M1362 datapath_0/staticizer_1/staticizer_one_0[6]/inv_0/out datapath_0/staticizer_1/staticizer_one_0[6]/inv_2/out datapath_0/staticizer_1/staticizer_one_0[6]/new_latch_0/a_82_34# GND nfet w=5 l=2
+  ad=0 pd=0 as=0 ps=0
M1363 Vdd datapath_0/staticizer_1/staticizer_one_0[6]/inv_2/out datapath_0/staticizer_1/staticizer_one_0[6]/new_latch_0/a_82_52# Vdd pfet w=10 l=2
+  ad=0 pd=0 as=60 ps=32
M1364 datapath_0/staticizer_1/staticizer_one_0[7]/inv_0/out datapath_0/staticizer_1/staticizer_one_0[7]/internal GND GND nfet w=5 l=2
+  ad=60 pd=44 as=0 ps=0
M1365 datapath_0/staticizer_1/staticizer_one_0[7]/inv_0/out datapath_0/staticizer_1/staticizer_one_0[7]/internal Vdd Vdd pfet w=10 l=2
+  ad=120 pd=64 as=0 ps=0
M1366 datapath_0/staticizer_1/staticizer_one_0[7]/internal datapath_0/wz7 GND GND nfet w=5 l=2
+  ad=30 pd=22 as=0 ps=0
M1367 datapath_0/staticizer_1/staticizer_one_0[7]/internal datapath_0/wz7 Vdd Vdd pfet w=10 l=2
+  ad=60 pd=32 as=0 ps=0
M1368 datapath_0/staticizer_1/staticizer_one_0[7]/inv_2/out datapath_0/or4_0/out GND GND nfet w=5 l=2
+  ad=30 pd=22 as=0 ps=0
M1369 datapath_0/staticizer_1/staticizer_one_0[7]/inv_2/out datapath_0/or4_0/out Vdd Vdd pfet w=10 l=2
+  ad=60 pd=32 as=0 ps=0
M1370 GND datapath_0/staticizer_1/staticizer_one_0[7]/inv_2/out datapath_0/staticizer_1/staticizer_one_0[7]/new_latch_0/a_82_52# GND nfet w=5 l=2
+  ad=0 pd=0 as=30 ps=22
M1371 datapath_0/staticizer_1/staticizer_one_0[7]/new_latch_0/a_99_34# datapath_0/staticizer_1/staticizer_one_0[7]/new_latch_0/a_79_32# Vdd Vdd pfet w=10 l=2
+  ad=40 pd=28 as=0 ps=0
M1372 datapath_0/staticizer_1/staticizer_one_0[7]/new_latch_0/a_79_32# datapath_0/wz7 Vdd Vdd pfet w=10 l=2
+  ad=60 pd=32 as=0 ps=0
M1373 datapath_0/staticizer_1/staticizer_one_0[7]/inv_0/out datapath_0/staticizer_1/staticizer_one_0[7]/new_latch_0/a_82_52# datapath_0/staticizer_1/staticizer_one_0[7]/new_latch_0/a_99_34# Vdd pfet w=10 l=2
+  ad=0 pd=0 as=0 ps=0
M1374 datapath_0/staticizer_1/staticizer_one_0[7]/new_latch_0/a_82_34# datapath_0/staticizer_1/staticizer_one_0[7]/new_latch_0/a_79_32# GND GND nfet w=5 l=2
+  ad=20 pd=18 as=0 ps=0
M1375 datapath_0/staticizer_1/staticizer_one_0[7]/new_latch_0/a_79_32# datapath_0/wz7 GND GND nfet w=5 l=2
+  ad=30 pd=22 as=0 ps=0
M1376 datapath_0/staticizer_1/staticizer_one_0[7]/inv_0/out datapath_0/staticizer_1/staticizer_one_0[7]/inv_2/out datapath_0/staticizer_1/staticizer_one_0[7]/new_latch_0/a_82_34# GND nfet w=5 l=2
+  ad=0 pd=0 as=0 ps=0
M1377 Vdd datapath_0/staticizer_1/staticizer_one_0[7]/inv_2/out datapath_0/staticizer_1/staticizer_one_0[7]/new_latch_0/a_82_52# Vdd pfet w=10 l=2
+  ad=0 pd=0 as=60 ps=32
M1378 datapath_0/or4_0/nand2_0/A fsm_0/rfb datapath_0/or4_0/nor2_0/a_11_35# Vdd pfet w=18 l=2
+  ad=108 pd=48 as=126 ps=50
M1379 datapath_0/or4_0/nand2_0/A fsm_0/ld GND GND nfet w=12 l=2
+  ad=84 pd=38 as=0 ps=0
M1380 GND fsm_0/rfb datapath_0/or4_0/nand2_0/A GND nfet w=12 l=2
+  ad=0 pd=0 as=0 ps=0
M1381 datapath_0/or4_0/nor2_0/a_11_35# fsm_0/ld Vdd Vdd pfet w=18 l=2
+  ad=0 pd=0 as=0 ps=0
M1382 datapath_0/or4_0/nand2_0/B fsm_0/ros datapath_0/or4_0/nor2_2/a_11_35# Vdd pfet w=18 l=2
+  ad=108 pd=48 as=126 ps=50
M1383 datapath_0/or4_0/nand2_0/B datapath_0/ras GND GND nfet w=12 l=2
+  ad=84 pd=38 as=0 ps=0
M1384 GND fsm_0/ros datapath_0/or4_0/nand2_0/B GND nfet w=12 l=2
+  ad=0 pd=0 as=0 ps=0
M1385 datapath_0/or4_0/nor2_2/a_11_35# datapath_0/ras Vdd Vdd pfet w=18 l=2
+  ad=0 pd=0 as=0 ps=0
M1386 datapath_0/or4_0/nand2_0/a_7_10# datapath_0/or4_0/nand2_0/A GND GND nfet w=6 l=2
+  ad=42 pd=26 as=0 ps=0
M1387 datapath_0/or4_0/out datapath_0/or4_0/nand2_0/A Vdd Vdd pfet w=12 l=2
+  ad=84 pd=38 as=0 ps=0
M1388 datapath_0/or4_0/out datapath_0/or4_0/nand2_0/B datapath_0/or4_0/nand2_0/a_7_10# GND nfet w=6 l=2
+  ad=36 pd=24 as=0 ps=0
M1389 Vdd datapath_0/or4_0/nand2_0/B datapath_0/or4_0/out Vdd pfet w=12 l=2
+  ad=0 pd=0 as=0 ps=0
M1390 GND fsm_0/ld datapath_0/latch_0/latch_one_0[0]/new_latch_0/a_82_52# GND nfet w=5 l=2
+  ad=0 pd=0 as=30 ps=22
M1391 datapath_0/latch_0/latch_one_0[0]/new_latch_0/a_99_34# datapath_0/latch_0/latch_one_0[0]/new_latch_0/a_79_32# Vdd Vdd pfet w=10 l=2
+  ad=40 pd=28 as=0 ps=0
M1392 datapath_0/latch_0/latch_one_0[0]/new_latch_0/a_79_32# in0 Vdd Vdd pfet w=10 l=2
+  ad=60 pd=32 as=0 ps=0
M1393 datapath_0/wz0 datapath_0/latch_0/latch_one_0[0]/new_latch_0/a_82_52# datapath_0/latch_0/latch_one_0[0]/new_latch_0/a_99_34# Vdd pfet w=10 l=2
+  ad=240 pd=128 as=0 ps=0
M1394 datapath_0/latch_0/latch_one_0[0]/new_latch_0/a_82_34# datapath_0/latch_0/latch_one_0[0]/new_latch_0/a_79_32# GND GND nfet w=5 l=2
+  ad=20 pd=18 as=0 ps=0
M1395 datapath_0/latch_0/latch_one_0[0]/new_latch_0/a_79_32# in0 GND GND nfet w=5 l=2
+  ad=30 pd=22 as=0 ps=0
M1396 datapath_0/wz0 fsm_0/ld datapath_0/latch_0/latch_one_0[0]/new_latch_0/a_82_34# GND nfet w=5 l=2
+  ad=120 pd=88 as=0 ps=0
M1397 Vdd fsm_0/ld datapath_0/latch_0/latch_one_0[0]/new_latch_0/a_82_52# Vdd pfet w=10 l=2
+  ad=0 pd=0 as=60 ps=32
M1398 GND fsm_0/ld datapath_0/latch_0/latch_one_0[1]/new_latch_0/a_82_52# GND nfet w=5 l=2
+  ad=0 pd=0 as=30 ps=22
M1399 datapath_0/latch_0/latch_one_0[1]/new_latch_0/a_99_34# datapath_0/latch_0/latch_one_0[1]/new_latch_0/a_79_32# Vdd Vdd pfet w=10 l=2
+  ad=40 pd=28 as=0 ps=0
M1400 datapath_0/latch_0/latch_one_0[1]/new_latch_0/a_79_32# in1 Vdd Vdd pfet w=10 l=2
+  ad=60 pd=32 as=0 ps=0
M1401 datapath_0/wz1 datapath_0/latch_0/latch_one_0[1]/new_latch_0/a_82_52# datapath_0/latch_0/latch_one_0[1]/new_latch_0/a_99_34# Vdd pfet w=10 l=2
+  ad=240 pd=128 as=0 ps=0
M1402 datapath_0/latch_0/latch_one_0[1]/new_latch_0/a_82_34# datapath_0/latch_0/latch_one_0[1]/new_latch_0/a_79_32# GND GND nfet w=5 l=2
+  ad=20 pd=18 as=0 ps=0
M1403 datapath_0/latch_0/latch_one_0[1]/new_latch_0/a_79_32# in1 GND GND nfet w=5 l=2
+  ad=30 pd=22 as=0 ps=0
M1404 datapath_0/wz1 fsm_0/ld datapath_0/latch_0/latch_one_0[1]/new_latch_0/a_82_34# GND nfet w=5 l=2
+  ad=120 pd=88 as=0 ps=0
M1405 Vdd fsm_0/ld datapath_0/latch_0/latch_one_0[1]/new_latch_0/a_82_52# Vdd pfet w=10 l=2
+  ad=0 pd=0 as=60 ps=32
M1406 GND fsm_0/ld datapath_0/latch_0/latch_one_0[2]/new_latch_0/a_82_52# GND nfet w=5 l=2
+  ad=0 pd=0 as=30 ps=22
M1407 datapath_0/latch_0/latch_one_0[2]/new_latch_0/a_99_34# datapath_0/latch_0/latch_one_0[2]/new_latch_0/a_79_32# Vdd Vdd pfet w=10 l=2
+  ad=40 pd=28 as=0 ps=0
M1408 datapath_0/latch_0/latch_one_0[2]/new_latch_0/a_79_32# in2 Vdd Vdd pfet w=10 l=2
+  ad=60 pd=32 as=0 ps=0
M1409 datapath_0/wz2 datapath_0/latch_0/latch_one_0[2]/new_latch_0/a_82_52# datapath_0/latch_0/latch_one_0[2]/new_latch_0/a_99_34# Vdd pfet w=10 l=2
+  ad=240 pd=128 as=0 ps=0
M1410 datapath_0/latch_0/latch_one_0[2]/new_latch_0/a_82_34# datapath_0/latch_0/latch_one_0[2]/new_latch_0/a_79_32# GND GND nfet w=5 l=2
+  ad=20 pd=18 as=0 ps=0
M1411 datapath_0/latch_0/latch_one_0[2]/new_latch_0/a_79_32# in2 GND GND nfet w=5 l=2
+  ad=30 pd=22 as=0 ps=0
M1412 datapath_0/wz2 fsm_0/ld datapath_0/latch_0/latch_one_0[2]/new_latch_0/a_82_34# GND nfet w=5 l=2
+  ad=120 pd=88 as=0 ps=0
M1413 Vdd fsm_0/ld datapath_0/latch_0/latch_one_0[2]/new_latch_0/a_82_52# Vdd pfet w=10 l=2
+  ad=0 pd=0 as=60 ps=32
M1414 GND fsm_0/ld datapath_0/latch_0/latch_one_0[3]/new_latch_0/a_82_52# GND nfet w=5 l=2
+  ad=0 pd=0 as=30 ps=22
M1415 datapath_0/latch_0/latch_one_0[3]/new_latch_0/a_99_34# datapath_0/latch_0/latch_one_0[3]/new_latch_0/a_79_32# Vdd Vdd pfet w=10 l=2
+  ad=40 pd=28 as=0 ps=0
M1416 datapath_0/latch_0/latch_one_0[3]/new_latch_0/a_79_32# in3 Vdd Vdd pfet w=10 l=2
+  ad=60 pd=32 as=0 ps=0
M1417 datapath_0/wz3 datapath_0/latch_0/latch_one_0[3]/new_latch_0/a_82_52# datapath_0/latch_0/latch_one_0[3]/new_latch_0/a_99_34# Vdd pfet w=10 l=2
+  ad=240 pd=128 as=0 ps=0
M1418 datapath_0/latch_0/latch_one_0[3]/new_latch_0/a_82_34# datapath_0/latch_0/latch_one_0[3]/new_latch_0/a_79_32# GND GND nfet w=5 l=2
+  ad=20 pd=18 as=0 ps=0
M1419 datapath_0/latch_0/latch_one_0[3]/new_latch_0/a_79_32# in3 GND GND nfet w=5 l=2
+  ad=30 pd=22 as=0 ps=0
M1420 datapath_0/wz3 fsm_0/ld datapath_0/latch_0/latch_one_0[3]/new_latch_0/a_82_34# GND nfet w=5 l=2
+  ad=120 pd=88 as=0 ps=0
M1421 Vdd fsm_0/ld datapath_0/latch_0/latch_one_0[3]/new_latch_0/a_82_52# Vdd pfet w=10 l=2
+  ad=0 pd=0 as=60 ps=32
M1422 GND fsm_0/ld datapath_0/latch_0/latch_one_0[4]/new_latch_0/a_82_52# GND nfet w=5 l=2
+  ad=0 pd=0 as=30 ps=22
M1423 datapath_0/latch_0/latch_one_0[4]/new_latch_0/a_99_34# datapath_0/latch_0/latch_one_0[4]/new_latch_0/a_79_32# Vdd Vdd pfet w=10 l=2
+  ad=40 pd=28 as=0 ps=0
M1424 datapath_0/latch_0/latch_one_0[4]/new_latch_0/a_79_32# in4 Vdd Vdd pfet w=10 l=2
+  ad=60 pd=32 as=0 ps=0
M1425 datapath_0/wz4 datapath_0/latch_0/latch_one_0[4]/new_latch_0/a_82_52# datapath_0/latch_0/latch_one_0[4]/new_latch_0/a_99_34# Vdd pfet w=10 l=2
+  ad=240 pd=128 as=0 ps=0
M1426 datapath_0/latch_0/latch_one_0[4]/new_latch_0/a_82_34# datapath_0/latch_0/latch_one_0[4]/new_latch_0/a_79_32# GND GND nfet w=5 l=2
+  ad=20 pd=18 as=0 ps=0
M1427 datapath_0/latch_0/latch_one_0[4]/new_latch_0/a_79_32# in4 GND GND nfet w=5 l=2
+  ad=30 pd=22 as=0 ps=0
M1428 datapath_0/wz4 fsm_0/ld datapath_0/latch_0/latch_one_0[4]/new_latch_0/a_82_34# GND nfet w=5 l=2
+  ad=120 pd=88 as=0 ps=0
M1429 Vdd fsm_0/ld datapath_0/latch_0/latch_one_0[4]/new_latch_0/a_82_52# Vdd pfet w=10 l=2
+  ad=0 pd=0 as=60 ps=32
M1430 GND fsm_0/ld datapath_0/latch_0/latch_one_0[5]/new_latch_0/a_82_52# GND nfet w=5 l=2
+  ad=0 pd=0 as=30 ps=22
M1431 datapath_0/latch_0/latch_one_0[5]/new_latch_0/a_99_34# datapath_0/latch_0/latch_one_0[5]/new_latch_0/a_79_32# Vdd Vdd pfet w=10 l=2
+  ad=40 pd=28 as=0 ps=0
M1432 datapath_0/latch_0/latch_one_0[5]/new_latch_0/a_79_32# in5 Vdd Vdd pfet w=10 l=2
+  ad=60 pd=32 as=0 ps=0
M1433 datapath_0/wz5 datapath_0/latch_0/latch_one_0[5]/new_latch_0/a_82_52# datapath_0/latch_0/latch_one_0[5]/new_latch_0/a_99_34# Vdd pfet w=10 l=2
+  ad=240 pd=128 as=0 ps=0
M1434 datapath_0/latch_0/latch_one_0[5]/new_latch_0/a_82_34# datapath_0/latch_0/latch_one_0[5]/new_latch_0/a_79_32# GND GND nfet w=5 l=2
+  ad=20 pd=18 as=0 ps=0
M1435 datapath_0/latch_0/latch_one_0[5]/new_latch_0/a_79_32# in5 GND GND nfet w=5 l=2
+  ad=30 pd=22 as=0 ps=0
M1436 datapath_0/wz5 fsm_0/ld datapath_0/latch_0/latch_one_0[5]/new_latch_0/a_82_34# GND nfet w=5 l=2
+  ad=120 pd=88 as=0 ps=0
M1437 Vdd fsm_0/ld datapath_0/latch_0/latch_one_0[5]/new_latch_0/a_82_52# Vdd pfet w=10 l=2
+  ad=0 pd=0 as=60 ps=32
M1438 GND fsm_0/ld datapath_0/latch_0/latch_one_0[6]/new_latch_0/a_82_52# GND nfet w=5 l=2
+  ad=0 pd=0 as=30 ps=22
M1439 datapath_0/latch_0/latch_one_0[6]/new_latch_0/a_99_34# datapath_0/latch_0/latch_one_0[6]/new_latch_0/a_79_32# Vdd Vdd pfet w=10 l=2
+  ad=40 pd=28 as=0 ps=0
M1440 datapath_0/latch_0/latch_one_0[6]/new_latch_0/a_79_32# in6 Vdd Vdd pfet w=10 l=2
+  ad=60 pd=32 as=0 ps=0
M1441 datapath_0/wz6 datapath_0/latch_0/latch_one_0[6]/new_latch_0/a_82_52# datapath_0/latch_0/latch_one_0[6]/new_latch_0/a_99_34# Vdd pfet w=10 l=2
+  ad=240 pd=128 as=0 ps=0
M1442 datapath_0/latch_0/latch_one_0[6]/new_latch_0/a_82_34# datapath_0/latch_0/latch_one_0[6]/new_latch_0/a_79_32# GND GND nfet w=5 l=2
+  ad=20 pd=18 as=0 ps=0
M1443 datapath_0/latch_0/latch_one_0[6]/new_latch_0/a_79_32# in6 GND GND nfet w=5 l=2
+  ad=30 pd=22 as=0 ps=0
M1444 datapath_0/wz6 fsm_0/ld datapath_0/latch_0/latch_one_0[6]/new_latch_0/a_82_34# GND nfet w=5 l=2
+  ad=120 pd=88 as=0 ps=0
M1445 Vdd fsm_0/ld datapath_0/latch_0/latch_one_0[6]/new_latch_0/a_82_52# Vdd pfet w=10 l=2
+  ad=0 pd=0 as=60 ps=32
M1446 GND fsm_0/ld datapath_0/latch_0/latch_one_0[7]/new_latch_0/a_82_52# GND nfet w=5 l=2
+  ad=0 pd=0 as=30 ps=22
M1447 datapath_0/latch_0/latch_one_0[7]/new_latch_0/a_99_34# datapath_0/latch_0/latch_one_0[7]/new_latch_0/a_79_32# Vdd Vdd pfet w=10 l=2
+  ad=40 pd=28 as=0 ps=0
M1448 datapath_0/latch_0/latch_one_0[7]/new_latch_0/a_79_32# in7 Vdd Vdd pfet w=10 l=2
+  ad=60 pd=32 as=0 ps=0
M1449 datapath_0/wz7 datapath_0/latch_0/latch_one_0[7]/new_latch_0/a_82_52# datapath_0/latch_0/latch_one_0[7]/new_latch_0/a_99_34# Vdd pfet w=10 l=2
+  ad=240 pd=128 as=0 ps=0
M1450 datapath_0/latch_0/latch_one_0[7]/new_latch_0/a_82_34# datapath_0/latch_0/latch_one_0[7]/new_latch_0/a_79_32# GND GND nfet w=5 l=2
+  ad=20 pd=18 as=0 ps=0
M1451 datapath_0/latch_0/latch_one_0[7]/new_latch_0/a_79_32# in7 GND GND nfet w=5 l=2
+  ad=30 pd=22 as=0 ps=0
M1452 datapath_0/wz7 fsm_0/ld datapath_0/latch_0/latch_one_0[7]/new_latch_0/a_82_34# GND nfet w=5 l=2
+  ad=120 pd=88 as=0 ps=0
M1453 Vdd fsm_0/ld datapath_0/latch_0/latch_one_0[7]/new_latch_0/a_82_52# Vdd pfet w=10 l=2
+  ad=0 pd=0 as=60 ps=32
M1454 GND fsm_0/rfb datapath_0/latch_1/latch_one_0[0]/new_latch_0/a_82_52# GND nfet w=5 l=2
+  ad=0 pd=0 as=30 ps=22
M1455 datapath_0/latch_1/latch_one_0[0]/new_latch_0/a_99_34# datapath_0/latch_1/latch_one_0[0]/new_latch_0/a_79_32# Vdd Vdd pfet w=10 l=2
+  ad=40 pd=28 as=0 ps=0
M1456 datapath_0/latch_1/latch_one_0[0]/new_latch_0/a_79_32# datapath_0/latch_1/in0 Vdd Vdd pfet w=10 l=2
+  ad=60 pd=32 as=0 ps=0
M1457 datapath_0/wz0 datapath_0/latch_1/latch_one_0[0]/new_latch_0/a_82_52# datapath_0/latch_1/latch_one_0[0]/new_latch_0/a_99_34# Vdd pfet w=10 l=2
+  ad=0 pd=0 as=0 ps=0
M1458 datapath_0/latch_1/latch_one_0[0]/new_latch_0/a_82_34# datapath_0/latch_1/latch_one_0[0]/new_latch_0/a_79_32# GND GND nfet w=5 l=2
+  ad=20 pd=18 as=0 ps=0
M1459 datapath_0/latch_1/latch_one_0[0]/new_latch_0/a_79_32# datapath_0/latch_1/in0 GND GND nfet w=5 l=2
+  ad=30 pd=22 as=0 ps=0
M1460 datapath_0/wz0 fsm_0/rfb datapath_0/latch_1/latch_one_0[0]/new_latch_0/a_82_34# GND nfet w=5 l=2
+  ad=0 pd=0 as=0 ps=0
M1461 Vdd fsm_0/rfb datapath_0/latch_1/latch_one_0[0]/new_latch_0/a_82_52# Vdd pfet w=10 l=2
+  ad=0 pd=0 as=60 ps=32
M1462 GND fsm_0/rfb datapath_0/latch_1/latch_one_0[1]/new_latch_0/a_82_52# GND nfet w=5 l=2
+  ad=0 pd=0 as=30 ps=22
M1463 datapath_0/latch_1/latch_one_0[1]/new_latch_0/a_99_34# datapath_0/latch_1/latch_one_0[1]/new_latch_0/a_79_32# Vdd Vdd pfet w=10 l=2
+  ad=40 pd=28 as=0 ps=0
M1464 datapath_0/latch_1/latch_one_0[1]/new_latch_0/a_79_32# datapath_0/latch_1/in1 Vdd Vdd pfet w=10 l=2
+  ad=60 pd=32 as=0 ps=0
M1465 datapath_0/wz1 datapath_0/latch_1/latch_one_0[1]/new_latch_0/a_82_52# datapath_0/latch_1/latch_one_0[1]/new_latch_0/a_99_34# Vdd pfet w=10 l=2
+  ad=0 pd=0 as=0 ps=0
M1466 datapath_0/latch_1/latch_one_0[1]/new_latch_0/a_82_34# datapath_0/latch_1/latch_one_0[1]/new_latch_0/a_79_32# GND GND nfet w=5 l=2
+  ad=20 pd=18 as=0 ps=0
M1467 datapath_0/latch_1/latch_one_0[1]/new_latch_0/a_79_32# datapath_0/latch_1/in1 GND GND nfet w=5 l=2
+  ad=30 pd=22 as=0 ps=0
M1468 datapath_0/wz1 fsm_0/rfb datapath_0/latch_1/latch_one_0[1]/new_latch_0/a_82_34# GND nfet w=5 l=2
+  ad=0 pd=0 as=0 ps=0
M1469 Vdd fsm_0/rfb datapath_0/latch_1/latch_one_0[1]/new_latch_0/a_82_52# Vdd pfet w=10 l=2
+  ad=0 pd=0 as=60 ps=32
M1470 GND fsm_0/rfb datapath_0/latch_1/latch_one_0[2]/new_latch_0/a_82_52# GND nfet w=5 l=2
+  ad=0 pd=0 as=30 ps=22
M1471 datapath_0/latch_1/latch_one_0[2]/new_latch_0/a_99_34# datapath_0/latch_1/latch_one_0[2]/new_latch_0/a_79_32# Vdd Vdd pfet w=10 l=2
+  ad=40 pd=28 as=0 ps=0
M1472 datapath_0/latch_1/latch_one_0[2]/new_latch_0/a_79_32# datapath_0/latch_1/in2 Vdd Vdd pfet w=10 l=2
+  ad=60 pd=32 as=0 ps=0
M1473 datapath_0/wz2 datapath_0/latch_1/latch_one_0[2]/new_latch_0/a_82_52# datapath_0/latch_1/latch_one_0[2]/new_latch_0/a_99_34# Vdd pfet w=10 l=2
+  ad=0 pd=0 as=0 ps=0
M1474 datapath_0/latch_1/latch_one_0[2]/new_latch_0/a_82_34# datapath_0/latch_1/latch_one_0[2]/new_latch_0/a_79_32# GND GND nfet w=5 l=2
+  ad=20 pd=18 as=0 ps=0
M1475 datapath_0/latch_1/latch_one_0[2]/new_latch_0/a_79_32# datapath_0/latch_1/in2 GND GND nfet w=5 l=2
+  ad=30 pd=22 as=0 ps=0
M1476 datapath_0/wz2 fsm_0/rfb datapath_0/latch_1/latch_one_0[2]/new_latch_0/a_82_34# GND nfet w=5 l=2
+  ad=0 pd=0 as=0 ps=0
M1477 Vdd fsm_0/rfb datapath_0/latch_1/latch_one_0[2]/new_latch_0/a_82_52# Vdd pfet w=10 l=2
+  ad=0 pd=0 as=60 ps=32
M1478 GND fsm_0/rfb datapath_0/latch_1/latch_one_0[3]/new_latch_0/a_82_52# GND nfet w=5 l=2
+  ad=0 pd=0 as=30 ps=22
M1479 datapath_0/latch_1/latch_one_0[3]/new_latch_0/a_99_34# datapath_0/latch_1/latch_one_0[3]/new_latch_0/a_79_32# Vdd Vdd pfet w=10 l=2
+  ad=40 pd=28 as=0 ps=0
M1480 datapath_0/latch_1/latch_one_0[3]/new_latch_0/a_79_32# datapath_0/latch_1/in3 Vdd Vdd pfet w=10 l=2
+  ad=60 pd=32 as=0 ps=0
M1481 datapath_0/wz3 datapath_0/latch_1/latch_one_0[3]/new_latch_0/a_82_52# datapath_0/latch_1/latch_one_0[3]/new_latch_0/a_99_34# Vdd pfet w=10 l=2
+  ad=0 pd=0 as=0 ps=0
M1482 datapath_0/latch_1/latch_one_0[3]/new_latch_0/a_82_34# datapath_0/latch_1/latch_one_0[3]/new_latch_0/a_79_32# GND GND nfet w=5 l=2
+  ad=20 pd=18 as=0 ps=0
M1483 datapath_0/latch_1/latch_one_0[3]/new_latch_0/a_79_32# datapath_0/latch_1/in3 GND GND nfet w=5 l=2
+  ad=30 pd=22 as=0 ps=0
M1484 datapath_0/wz3 fsm_0/rfb datapath_0/latch_1/latch_one_0[3]/new_latch_0/a_82_34# GND nfet w=5 l=2
+  ad=0 pd=0 as=0 ps=0
M1485 Vdd fsm_0/rfb datapath_0/latch_1/latch_one_0[3]/new_latch_0/a_82_52# Vdd pfet w=10 l=2
+  ad=0 pd=0 as=60 ps=32
M1486 GND fsm_0/rfb datapath_0/latch_1/latch_one_0[4]/new_latch_0/a_82_52# GND nfet w=5 l=2
+  ad=0 pd=0 as=30 ps=22
M1487 datapath_0/latch_1/latch_one_0[4]/new_latch_0/a_99_34# datapath_0/latch_1/latch_one_0[4]/new_latch_0/a_79_32# Vdd Vdd pfet w=10 l=2
+  ad=40 pd=28 as=0 ps=0
M1488 datapath_0/latch_1/latch_one_0[4]/new_latch_0/a_79_32# datapath_0/latch_1/in4 Vdd Vdd pfet w=10 l=2
+  ad=60 pd=32 as=0 ps=0
M1489 datapath_0/wz4 datapath_0/latch_1/latch_one_0[4]/new_latch_0/a_82_52# datapath_0/latch_1/latch_one_0[4]/new_latch_0/a_99_34# Vdd pfet w=10 l=2
+  ad=0 pd=0 as=0 ps=0
M1490 datapath_0/latch_1/latch_one_0[4]/new_latch_0/a_82_34# datapath_0/latch_1/latch_one_0[4]/new_latch_0/a_79_32# GND GND nfet w=5 l=2
+  ad=20 pd=18 as=0 ps=0
M1491 datapath_0/latch_1/latch_one_0[4]/new_latch_0/a_79_32# datapath_0/latch_1/in4 GND GND nfet w=5 l=2
+  ad=30 pd=22 as=0 ps=0
M1492 datapath_0/wz4 fsm_0/rfb datapath_0/latch_1/latch_one_0[4]/new_latch_0/a_82_34# GND nfet w=5 l=2
+  ad=0 pd=0 as=0 ps=0
M1493 Vdd fsm_0/rfb datapath_0/latch_1/latch_one_0[4]/new_latch_0/a_82_52# Vdd pfet w=10 l=2
+  ad=0 pd=0 as=60 ps=32
M1494 GND fsm_0/rfb datapath_0/latch_1/latch_one_0[5]/new_latch_0/a_82_52# GND nfet w=5 l=2
+  ad=0 pd=0 as=30 ps=22
M1495 datapath_0/latch_1/latch_one_0[5]/new_latch_0/a_99_34# datapath_0/latch_1/latch_one_0[5]/new_latch_0/a_79_32# Vdd Vdd pfet w=10 l=2
+  ad=40 pd=28 as=0 ps=0
M1496 datapath_0/latch_1/latch_one_0[5]/new_latch_0/a_79_32# datapath_0/latch_1/in5 Vdd Vdd pfet w=10 l=2
+  ad=60 pd=32 as=0 ps=0
M1497 datapath_0/wz5 datapath_0/latch_1/latch_one_0[5]/new_latch_0/a_82_52# datapath_0/latch_1/latch_one_0[5]/new_latch_0/a_99_34# Vdd pfet w=10 l=2
+  ad=0 pd=0 as=0 ps=0
M1498 datapath_0/latch_1/latch_one_0[5]/new_latch_0/a_82_34# datapath_0/latch_1/latch_one_0[5]/new_latch_0/a_79_32# GND GND nfet w=5 l=2
+  ad=20 pd=18 as=0 ps=0
M1499 datapath_0/latch_1/latch_one_0[5]/new_latch_0/a_79_32# datapath_0/latch_1/in5 GND GND nfet w=5 l=2
+  ad=30 pd=22 as=0 ps=0
M1500 datapath_0/wz5 fsm_0/rfb datapath_0/latch_1/latch_one_0[5]/new_latch_0/a_82_34# GND nfet w=5 l=2
+  ad=0 pd=0 as=0 ps=0
M1501 Vdd fsm_0/rfb datapath_0/latch_1/latch_one_0[5]/new_latch_0/a_82_52# Vdd pfet w=10 l=2
+  ad=0 pd=0 as=60 ps=32
M1502 GND fsm_0/rfb datapath_0/latch_1/latch_one_0[6]/new_latch_0/a_82_52# GND nfet w=5 l=2
+  ad=0 pd=0 as=30 ps=22
M1503 datapath_0/latch_1/latch_one_0[6]/new_latch_0/a_99_34# datapath_0/latch_1/latch_one_0[6]/new_latch_0/a_79_32# Vdd Vdd pfet w=10 l=2
+  ad=40 pd=28 as=0 ps=0
M1504 datapath_0/latch_1/latch_one_0[6]/new_latch_0/a_79_32# datapath_0/latch_1/in6 Vdd Vdd pfet w=10 l=2
+  ad=60 pd=32 as=0 ps=0
M1505 datapath_0/wz6 datapath_0/latch_1/latch_one_0[6]/new_latch_0/a_82_52# datapath_0/latch_1/latch_one_0[6]/new_latch_0/a_99_34# Vdd pfet w=10 l=2
+  ad=0 pd=0 as=0 ps=0
M1506 datapath_0/latch_1/latch_one_0[6]/new_latch_0/a_82_34# datapath_0/latch_1/latch_one_0[6]/new_latch_0/a_79_32# GND GND nfet w=5 l=2
+  ad=20 pd=18 as=0 ps=0
M1507 datapath_0/latch_1/latch_one_0[6]/new_latch_0/a_79_32# datapath_0/latch_1/in6 GND GND nfet w=5 l=2
+  ad=30 pd=22 as=0 ps=0
M1508 datapath_0/wz6 fsm_0/rfb datapath_0/latch_1/latch_one_0[6]/new_latch_0/a_82_34# GND nfet w=5 l=2
+  ad=0 pd=0 as=0 ps=0
M1509 Vdd fsm_0/rfb datapath_0/latch_1/latch_one_0[6]/new_latch_0/a_82_52# Vdd pfet w=10 l=2
+  ad=0 pd=0 as=60 ps=32
M1510 GND fsm_0/rfb datapath_0/latch_1/latch_one_0[7]/new_latch_0/a_82_52# GND nfet w=5 l=2
+  ad=0 pd=0 as=30 ps=22
M1511 datapath_0/latch_1/latch_one_0[7]/new_latch_0/a_99_34# datapath_0/latch_1/latch_one_0[7]/new_latch_0/a_79_32# Vdd Vdd pfet w=10 l=2
+  ad=40 pd=28 as=0 ps=0
M1512 datapath_0/latch_1/latch_one_0[7]/new_latch_0/a_79_32# datapath_0/latch_1/in7 Vdd Vdd pfet w=10 l=2
+  ad=60 pd=32 as=0 ps=0
M1513 datapath_0/wz7 datapath_0/latch_1/latch_one_0[7]/new_latch_0/a_82_52# datapath_0/latch_1/latch_one_0[7]/new_latch_0/a_99_34# Vdd pfet w=10 l=2
+  ad=0 pd=0 as=0 ps=0
M1514 datapath_0/latch_1/latch_one_0[7]/new_latch_0/a_82_34# datapath_0/latch_1/latch_one_0[7]/new_latch_0/a_79_32# GND GND nfet w=5 l=2
+  ad=20 pd=18 as=0 ps=0
M1515 datapath_0/latch_1/latch_one_0[7]/new_latch_0/a_79_32# datapath_0/latch_1/in7 GND GND nfet w=5 l=2
+  ad=30 pd=22 as=0 ps=0
M1516 datapath_0/wz7 fsm_0/rfb datapath_0/latch_1/latch_one_0[7]/new_latch_0/a_82_34# GND nfet w=5 l=2
+  ad=0 pd=0 as=0 ps=0
M1517 Vdd fsm_0/rfb datapath_0/latch_1/latch_one_0[7]/new_latch_0/a_82_52# Vdd pfet w=10 l=2
+  ad=0 pd=0 as=60 ps=32
M1518 GND datapath_0/ras datapath_0/latch_2/latch_one_0[0]/new_latch_0/a_82_52# GND nfet w=5 l=2
+  ad=0 pd=0 as=30 ps=22
M1519 datapath_0/latch_2/latch_one_0[0]/new_latch_0/a_99_34# datapath_0/latch_2/latch_one_0[0]/new_latch_0/a_79_32# Vdd Vdd pfet w=10 l=2
+  ad=40 pd=28 as=0 ps=0
M1520 datapath_0/latch_2/latch_one_0[0]/new_latch_0/a_79_32# datapath_0/latch_2/in0 Vdd Vdd pfet w=10 l=2
+  ad=60 pd=32 as=0 ps=0
M1521 datapath_0/wz0 datapath_0/latch_2/latch_one_0[0]/new_latch_0/a_82_52# datapath_0/latch_2/latch_one_0[0]/new_latch_0/a_99_34# Vdd pfet w=10 l=2
+  ad=0 pd=0 as=0 ps=0
M1522 datapath_0/latch_2/latch_one_0[0]/new_latch_0/a_82_34# datapath_0/latch_2/latch_one_0[0]/new_latch_0/a_79_32# GND GND nfet w=5 l=2
+  ad=20 pd=18 as=0 ps=0
M1523 datapath_0/latch_2/latch_one_0[0]/new_latch_0/a_79_32# datapath_0/latch_2/in0 GND GND nfet w=5 l=2
+  ad=30 pd=22 as=0 ps=0
M1524 datapath_0/wz0 datapath_0/ras datapath_0/latch_2/latch_one_0[0]/new_latch_0/a_82_34# GND nfet w=5 l=2
+  ad=0 pd=0 as=0 ps=0
M1525 Vdd datapath_0/ras datapath_0/latch_2/latch_one_0[0]/new_latch_0/a_82_52# Vdd pfet w=10 l=2
+  ad=0 pd=0 as=60 ps=32
M1526 GND datapath_0/ras datapath_0/latch_2/latch_one_0[1]/new_latch_0/a_82_52# GND nfet w=5 l=2
+  ad=0 pd=0 as=30 ps=22
M1527 datapath_0/latch_2/latch_one_0[1]/new_latch_0/a_99_34# datapath_0/latch_2/latch_one_0[1]/new_latch_0/a_79_32# Vdd Vdd pfet w=10 l=2
+  ad=40 pd=28 as=0 ps=0
M1528 datapath_0/latch_2/latch_one_0[1]/new_latch_0/a_79_32# datapath_0/latch_2/in1 Vdd Vdd pfet w=10 l=2
+  ad=60 pd=32 as=0 ps=0
M1529 datapath_0/wz1 datapath_0/latch_2/latch_one_0[1]/new_latch_0/a_82_52# datapath_0/latch_2/latch_one_0[1]/new_latch_0/a_99_34# Vdd pfet w=10 l=2
+  ad=0 pd=0 as=0 ps=0
M1530 datapath_0/latch_2/latch_one_0[1]/new_latch_0/a_82_34# datapath_0/latch_2/latch_one_0[1]/new_latch_0/a_79_32# GND GND nfet w=5 l=2
+  ad=20 pd=18 as=0 ps=0
M1531 datapath_0/latch_2/latch_one_0[1]/new_latch_0/a_79_32# datapath_0/latch_2/in1 GND GND nfet w=5 l=2
+  ad=30 pd=22 as=0 ps=0
M1532 datapath_0/wz1 datapath_0/ras datapath_0/latch_2/latch_one_0[1]/new_latch_0/a_82_34# GND nfet w=5 l=2
+  ad=0 pd=0 as=0 ps=0
M1533 Vdd datapath_0/ras datapath_0/latch_2/latch_one_0[1]/new_latch_0/a_82_52# Vdd pfet w=10 l=2
+  ad=0 pd=0 as=60 ps=32
M1534 GND datapath_0/ras datapath_0/latch_2/latch_one_0[2]/new_latch_0/a_82_52# GND nfet w=5 l=2
+  ad=0 pd=0 as=30 ps=22
M1535 datapath_0/latch_2/latch_one_0[2]/new_latch_0/a_99_34# datapath_0/latch_2/latch_one_0[2]/new_latch_0/a_79_32# Vdd Vdd pfet w=10 l=2
+  ad=40 pd=28 as=0 ps=0
M1536 datapath_0/latch_2/latch_one_0[2]/new_latch_0/a_79_32# datapath_0/latch_2/in2 Vdd Vdd pfet w=10 l=2
+  ad=60 pd=32 as=0 ps=0
M1537 datapath_0/wz2 datapath_0/latch_2/latch_one_0[2]/new_latch_0/a_82_52# datapath_0/latch_2/latch_one_0[2]/new_latch_0/a_99_34# Vdd pfet w=10 l=2
+  ad=0 pd=0 as=0 ps=0
M1538 datapath_0/latch_2/latch_one_0[2]/new_latch_0/a_82_34# datapath_0/latch_2/latch_one_0[2]/new_latch_0/a_79_32# GND GND nfet w=5 l=2
+  ad=20 pd=18 as=0 ps=0
M1539 datapath_0/latch_2/latch_one_0[2]/new_latch_0/a_79_32# datapath_0/latch_2/in2 GND GND nfet w=5 l=2
+  ad=30 pd=22 as=0 ps=0
M1540 datapath_0/wz2 datapath_0/ras datapath_0/latch_2/latch_one_0[2]/new_latch_0/a_82_34# GND nfet w=5 l=2
+  ad=0 pd=0 as=0 ps=0
M1541 Vdd datapath_0/ras datapath_0/latch_2/latch_one_0[2]/new_latch_0/a_82_52# Vdd pfet w=10 l=2
+  ad=0 pd=0 as=60 ps=32
M1542 GND datapath_0/ras datapath_0/latch_2/latch_one_0[3]/new_latch_0/a_82_52# GND nfet w=5 l=2
+  ad=0 pd=0 as=30 ps=22
M1543 datapath_0/latch_2/latch_one_0[3]/new_latch_0/a_99_34# datapath_0/latch_2/latch_one_0[3]/new_latch_0/a_79_32# Vdd Vdd pfet w=10 l=2
+  ad=40 pd=28 as=0 ps=0
M1544 datapath_0/latch_2/latch_one_0[3]/new_latch_0/a_79_32# datapath_0/latch_2/in3 Vdd Vdd pfet w=10 l=2
+  ad=60 pd=32 as=0 ps=0
M1545 datapath_0/wz3 datapath_0/latch_2/latch_one_0[3]/new_latch_0/a_82_52# datapath_0/latch_2/latch_one_0[3]/new_latch_0/a_99_34# Vdd pfet w=10 l=2
+  ad=0 pd=0 as=0 ps=0
M1546 datapath_0/latch_2/latch_one_0[3]/new_latch_0/a_82_34# datapath_0/latch_2/latch_one_0[3]/new_latch_0/a_79_32# GND GND nfet w=5 l=2
+  ad=20 pd=18 as=0 ps=0
M1547 datapath_0/latch_2/latch_one_0[3]/new_latch_0/a_79_32# datapath_0/latch_2/in3 GND GND nfet w=5 l=2
+  ad=30 pd=22 as=0 ps=0
M1548 datapath_0/wz3 datapath_0/ras datapath_0/latch_2/latch_one_0[3]/new_latch_0/a_82_34# GND nfet w=5 l=2
+  ad=0 pd=0 as=0 ps=0
M1549 Vdd datapath_0/ras datapath_0/latch_2/latch_one_0[3]/new_latch_0/a_82_52# Vdd pfet w=10 l=2
+  ad=0 pd=0 as=60 ps=32
M1550 GND datapath_0/ras datapath_0/latch_2/latch_one_0[4]/new_latch_0/a_82_52# GND nfet w=5 l=2
+  ad=0 pd=0 as=30 ps=22
M1551 datapath_0/latch_2/latch_one_0[4]/new_latch_0/a_99_34# datapath_0/latch_2/latch_one_0[4]/new_latch_0/a_79_32# Vdd Vdd pfet w=10 l=2
+  ad=40 pd=28 as=0 ps=0
M1552 datapath_0/latch_2/latch_one_0[4]/new_latch_0/a_79_32# datapath_0/latch_2/in4 Vdd Vdd pfet w=10 l=2
+  ad=60 pd=32 as=0 ps=0
M1553 datapath_0/wz4 datapath_0/latch_2/latch_one_0[4]/new_latch_0/a_82_52# datapath_0/latch_2/latch_one_0[4]/new_latch_0/a_99_34# Vdd pfet w=10 l=2
+  ad=0 pd=0 as=0 ps=0
M1554 datapath_0/latch_2/latch_one_0[4]/new_latch_0/a_82_34# datapath_0/latch_2/latch_one_0[4]/new_latch_0/a_79_32# GND GND nfet w=5 l=2
+  ad=20 pd=18 as=0 ps=0
M1555 datapath_0/latch_2/latch_one_0[4]/new_latch_0/a_79_32# datapath_0/latch_2/in4 GND GND nfet w=5 l=2
+  ad=30 pd=22 as=0 ps=0
M1556 datapath_0/wz4 datapath_0/ras datapath_0/latch_2/latch_one_0[4]/new_latch_0/a_82_34# GND nfet w=5 l=2
+  ad=0 pd=0 as=0 ps=0
M1557 Vdd datapath_0/ras datapath_0/latch_2/latch_one_0[4]/new_latch_0/a_82_52# Vdd pfet w=10 l=2
+  ad=0 pd=0 as=60 ps=32
M1558 GND datapath_0/ras datapath_0/latch_2/latch_one_0[5]/new_latch_0/a_82_52# GND nfet w=5 l=2
+  ad=0 pd=0 as=30 ps=22
M1559 datapath_0/latch_2/latch_one_0[5]/new_latch_0/a_99_34# datapath_0/latch_2/latch_one_0[5]/new_latch_0/a_79_32# Vdd Vdd pfet w=10 l=2
+  ad=40 pd=28 as=0 ps=0
M1560 datapath_0/latch_2/latch_one_0[5]/new_latch_0/a_79_32# datapath_0/latch_2/in5 Vdd Vdd pfet w=10 l=2
+  ad=60 pd=32 as=0 ps=0
M1561 datapath_0/wz5 datapath_0/latch_2/latch_one_0[5]/new_latch_0/a_82_52# datapath_0/latch_2/latch_one_0[5]/new_latch_0/a_99_34# Vdd pfet w=10 l=2
+  ad=0 pd=0 as=0 ps=0
M1562 datapath_0/latch_2/latch_one_0[5]/new_latch_0/a_82_34# datapath_0/latch_2/latch_one_0[5]/new_latch_0/a_79_32# GND GND nfet w=5 l=2
+  ad=20 pd=18 as=0 ps=0
M1563 datapath_0/latch_2/latch_one_0[5]/new_latch_0/a_79_32# datapath_0/latch_2/in5 GND GND nfet w=5 l=2
+  ad=30 pd=22 as=0 ps=0
M1564 datapath_0/wz5 datapath_0/ras datapath_0/latch_2/latch_one_0[5]/new_latch_0/a_82_34# GND nfet w=5 l=2
+  ad=0 pd=0 as=0 ps=0
M1565 Vdd datapath_0/ras datapath_0/latch_2/latch_one_0[5]/new_latch_0/a_82_52# Vdd pfet w=10 l=2
+  ad=0 pd=0 as=60 ps=32
M1566 GND datapath_0/ras datapath_0/latch_2/latch_one_0[6]/new_latch_0/a_82_52# GND nfet w=5 l=2
+  ad=0 pd=0 as=30 ps=22
M1567 datapath_0/latch_2/latch_one_0[6]/new_latch_0/a_99_34# datapath_0/latch_2/latch_one_0[6]/new_latch_0/a_79_32# Vdd Vdd pfet w=10 l=2
+  ad=40 pd=28 as=0 ps=0
M1568 datapath_0/latch_2/latch_one_0[6]/new_latch_0/a_79_32# datapath_0/latch_2/in6 Vdd Vdd pfet w=10 l=2
+  ad=60 pd=32 as=0 ps=0
M1569 datapath_0/wz6 datapath_0/latch_2/latch_one_0[6]/new_latch_0/a_82_52# datapath_0/latch_2/latch_one_0[6]/new_latch_0/a_99_34# Vdd pfet w=10 l=2
+  ad=0 pd=0 as=0 ps=0
M1570 datapath_0/latch_2/latch_one_0[6]/new_latch_0/a_82_34# datapath_0/latch_2/latch_one_0[6]/new_latch_0/a_79_32# GND GND nfet w=5 l=2
+  ad=20 pd=18 as=0 ps=0
M1571 datapath_0/latch_2/latch_one_0[6]/new_latch_0/a_79_32# datapath_0/latch_2/in6 GND GND nfet w=5 l=2
+  ad=30 pd=22 as=0 ps=0
M1572 datapath_0/wz6 datapath_0/ras datapath_0/latch_2/latch_one_0[6]/new_latch_0/a_82_34# GND nfet w=5 l=2
+  ad=0 pd=0 as=0 ps=0
M1573 Vdd datapath_0/ras datapath_0/latch_2/latch_one_0[6]/new_latch_0/a_82_52# Vdd pfet w=10 l=2
+  ad=0 pd=0 as=60 ps=32
M1574 GND datapath_0/ras datapath_0/latch_2/latch_one_0[7]/new_latch_0/a_82_52# GND nfet w=5 l=2
+  ad=0 pd=0 as=30 ps=22
M1575 datapath_0/latch_2/latch_one_0[7]/new_latch_0/a_99_34# datapath_0/latch_2/latch_one_0[7]/new_latch_0/a_79_32# Vdd Vdd pfet w=10 l=2
+  ad=40 pd=28 as=0 ps=0
M1576 datapath_0/latch_2/latch_one_0[7]/new_latch_0/a_79_32# datapath_0/latch_2/in7 Vdd Vdd pfet w=10 l=2
+  ad=60 pd=32 as=0 ps=0
M1577 datapath_0/wz7 datapath_0/latch_2/latch_one_0[7]/new_latch_0/a_82_52# datapath_0/latch_2/latch_one_0[7]/new_latch_0/a_99_34# Vdd pfet w=10 l=2
+  ad=0 pd=0 as=0 ps=0
M1578 datapath_0/latch_2/latch_one_0[7]/new_latch_0/a_82_34# datapath_0/latch_2/latch_one_0[7]/new_latch_0/a_79_32# GND GND nfet w=5 l=2
+  ad=20 pd=18 as=0 ps=0
M1579 datapath_0/latch_2/latch_one_0[7]/new_latch_0/a_79_32# datapath_0/latch_2/in7 GND GND nfet w=5 l=2
+  ad=30 pd=22 as=0 ps=0
M1580 datapath_0/wz7 datapath_0/ras datapath_0/latch_2/latch_one_0[7]/new_latch_0/a_82_34# GND nfet w=5 l=2
+  ad=0 pd=0 as=0 ps=0
M1581 Vdd datapath_0/ras datapath_0/latch_2/latch_one_0[7]/new_latch_0/a_82_52# Vdd pfet w=10 l=2
+  ad=0 pd=0 as=60 ps=32
M1582 GND fsm_0/ros datapath_0/latch_3/latch_one_0[0]/new_latch_0/a_82_52# GND nfet w=5 l=2
+  ad=0 pd=0 as=30 ps=22
M1583 datapath_0/latch_3/latch_one_0[0]/new_latch_0/a_99_34# datapath_0/latch_3/latch_one_0[0]/new_latch_0/a_79_32# Vdd Vdd pfet w=10 l=2
+  ad=40 pd=28 as=0 ps=0
M1584 datapath_0/latch_3/latch_one_0[0]/new_latch_0/a_79_32# datapath_0/so0 Vdd Vdd pfet w=10 l=2
+  ad=60 pd=32 as=0 ps=0
M1585 datapath_0/wz0 datapath_0/latch_3/latch_one_0[0]/new_latch_0/a_82_52# datapath_0/latch_3/latch_one_0[0]/new_latch_0/a_99_34# Vdd pfet w=10 l=2
+  ad=0 pd=0 as=0 ps=0
M1586 datapath_0/latch_3/latch_one_0[0]/new_latch_0/a_82_34# datapath_0/latch_3/latch_one_0[0]/new_latch_0/a_79_32# GND GND nfet w=5 l=2
+  ad=20 pd=18 as=0 ps=0
M1587 datapath_0/latch_3/latch_one_0[0]/new_latch_0/a_79_32# datapath_0/so0 GND GND nfet w=5 l=2
+  ad=30 pd=22 as=0 ps=0
M1588 datapath_0/wz0 fsm_0/ros datapath_0/latch_3/latch_one_0[0]/new_latch_0/a_82_34# GND nfet w=5 l=2
+  ad=0 pd=0 as=0 ps=0
M1589 Vdd fsm_0/ros datapath_0/latch_3/latch_one_0[0]/new_latch_0/a_82_52# Vdd pfet w=10 l=2
+  ad=0 pd=0 as=60 ps=32
M1590 GND fsm_0/ros datapath_0/latch_3/latch_one_0[1]/new_latch_0/a_82_52# GND nfet w=5 l=2
+  ad=0 pd=0 as=30 ps=22
M1591 datapath_0/latch_3/latch_one_0[1]/new_latch_0/a_99_34# datapath_0/latch_3/latch_one_0[1]/new_latch_0/a_79_32# Vdd Vdd pfet w=10 l=2
+  ad=40 pd=28 as=0 ps=0
M1592 datapath_0/latch_3/latch_one_0[1]/new_latch_0/a_79_32# datapath_0/so1 Vdd Vdd pfet w=10 l=2
+  ad=60 pd=32 as=0 ps=0
M1593 datapath_0/wz1 datapath_0/latch_3/latch_one_0[1]/new_latch_0/a_82_52# datapath_0/latch_3/latch_one_0[1]/new_latch_0/a_99_34# Vdd pfet w=10 l=2
+  ad=0 pd=0 as=0 ps=0
M1594 datapath_0/latch_3/latch_one_0[1]/new_latch_0/a_82_34# datapath_0/latch_3/latch_one_0[1]/new_latch_0/a_79_32# GND GND nfet w=5 l=2
+  ad=20 pd=18 as=0 ps=0
M1595 datapath_0/latch_3/latch_one_0[1]/new_latch_0/a_79_32# datapath_0/so1 GND GND nfet w=5 l=2
+  ad=30 pd=22 as=0 ps=0
M1596 datapath_0/wz1 fsm_0/ros datapath_0/latch_3/latch_one_0[1]/new_latch_0/a_82_34# GND nfet w=5 l=2
+  ad=0 pd=0 as=0 ps=0
M1597 Vdd fsm_0/ros datapath_0/latch_3/latch_one_0[1]/new_latch_0/a_82_52# Vdd pfet w=10 l=2
+  ad=0 pd=0 as=60 ps=32
M1598 GND fsm_0/ros datapath_0/latch_3/latch_one_0[2]/new_latch_0/a_82_52# GND nfet w=5 l=2
+  ad=0 pd=0 as=30 ps=22
M1599 datapath_0/latch_3/latch_one_0[2]/new_latch_0/a_99_34# datapath_0/latch_3/latch_one_0[2]/new_latch_0/a_79_32# Vdd Vdd pfet w=10 l=2
+  ad=40 pd=28 as=0 ps=0
M1600 datapath_0/latch_3/latch_one_0[2]/new_latch_0/a_79_32# datapath_0/so2 Vdd Vdd pfet w=10 l=2
+  ad=60 pd=32 as=0 ps=0
M1601 datapath_0/wz2 datapath_0/latch_3/latch_one_0[2]/new_latch_0/a_82_52# datapath_0/latch_3/latch_one_0[2]/new_latch_0/a_99_34# Vdd pfet w=10 l=2
+  ad=0 pd=0 as=0 ps=0
M1602 datapath_0/latch_3/latch_one_0[2]/new_latch_0/a_82_34# datapath_0/latch_3/latch_one_0[2]/new_latch_0/a_79_32# GND GND nfet w=5 l=2
+  ad=20 pd=18 as=0 ps=0
M1603 datapath_0/latch_3/latch_one_0[2]/new_latch_0/a_79_32# datapath_0/so2 GND GND nfet w=5 l=2
+  ad=30 pd=22 as=0 ps=0
M1604 datapath_0/wz2 fsm_0/ros datapath_0/latch_3/latch_one_0[2]/new_latch_0/a_82_34# GND nfet w=5 l=2
+  ad=0 pd=0 as=0 ps=0
M1605 Vdd fsm_0/ros datapath_0/latch_3/latch_one_0[2]/new_latch_0/a_82_52# Vdd pfet w=10 l=2
+  ad=0 pd=0 as=60 ps=32
M1606 GND fsm_0/ros datapath_0/latch_3/latch_one_0[3]/new_latch_0/a_82_52# GND nfet w=5 l=2
+  ad=0 pd=0 as=30 ps=22
M1607 datapath_0/latch_3/latch_one_0[3]/new_latch_0/a_99_34# datapath_0/latch_3/latch_one_0[3]/new_latch_0/a_79_32# Vdd Vdd pfet w=10 l=2
+  ad=40 pd=28 as=0 ps=0
M1608 datapath_0/latch_3/latch_one_0[3]/new_latch_0/a_79_32# datapath_0/so3 Vdd Vdd pfet w=10 l=2
+  ad=60 pd=32 as=0 ps=0
M1609 datapath_0/wz3 datapath_0/latch_3/latch_one_0[3]/new_latch_0/a_82_52# datapath_0/latch_3/latch_one_0[3]/new_latch_0/a_99_34# Vdd pfet w=10 l=2
+  ad=0 pd=0 as=0 ps=0
M1610 datapath_0/latch_3/latch_one_0[3]/new_latch_0/a_82_34# datapath_0/latch_3/latch_one_0[3]/new_latch_0/a_79_32# GND GND nfet w=5 l=2
+  ad=20 pd=18 as=0 ps=0
M1611 datapath_0/latch_3/latch_one_0[3]/new_latch_0/a_79_32# datapath_0/so3 GND GND nfet w=5 l=2
+  ad=30 pd=22 as=0 ps=0
M1612 datapath_0/wz3 fsm_0/ros datapath_0/latch_3/latch_one_0[3]/new_latch_0/a_82_34# GND nfet w=5 l=2
+  ad=0 pd=0 as=0 ps=0
M1613 Vdd fsm_0/ros datapath_0/latch_3/latch_one_0[3]/new_latch_0/a_82_52# Vdd pfet w=10 l=2
+  ad=0 pd=0 as=60 ps=32
M1614 GND fsm_0/ros datapath_0/latch_3/latch_one_0[4]/new_latch_0/a_82_52# GND nfet w=5 l=2
+  ad=0 pd=0 as=30 ps=22
M1615 datapath_0/latch_3/latch_one_0[4]/new_latch_0/a_99_34# datapath_0/latch_3/latch_one_0[4]/new_latch_0/a_79_32# Vdd Vdd pfet w=10 l=2
+  ad=40 pd=28 as=0 ps=0
M1616 datapath_0/latch_3/latch_one_0[4]/new_latch_0/a_79_32# datapath_0/so4 Vdd Vdd pfet w=10 l=2
+  ad=60 pd=32 as=0 ps=0
M1617 datapath_0/wz4 datapath_0/latch_3/latch_one_0[4]/new_latch_0/a_82_52# datapath_0/latch_3/latch_one_0[4]/new_latch_0/a_99_34# Vdd pfet w=10 l=2
+  ad=0 pd=0 as=0 ps=0
M1618 datapath_0/latch_3/latch_one_0[4]/new_latch_0/a_82_34# datapath_0/latch_3/latch_one_0[4]/new_latch_0/a_79_32# GND GND nfet w=5 l=2
+  ad=20 pd=18 as=0 ps=0
M1619 datapath_0/latch_3/latch_one_0[4]/new_latch_0/a_79_32# datapath_0/so4 GND GND nfet w=5 l=2
+  ad=30 pd=22 as=0 ps=0
M1620 datapath_0/wz4 fsm_0/ros datapath_0/latch_3/latch_one_0[4]/new_latch_0/a_82_34# GND nfet w=5 l=2
+  ad=0 pd=0 as=0 ps=0
M1621 Vdd fsm_0/ros datapath_0/latch_3/latch_one_0[4]/new_latch_0/a_82_52# Vdd pfet w=10 l=2
+  ad=0 pd=0 as=60 ps=32
M1622 GND fsm_0/ros datapath_0/latch_3/latch_one_0[5]/new_latch_0/a_82_52# GND nfet w=5 l=2
+  ad=0 pd=0 as=30 ps=22
M1623 datapath_0/latch_3/latch_one_0[5]/new_latch_0/a_99_34# datapath_0/latch_3/latch_one_0[5]/new_latch_0/a_79_32# Vdd Vdd pfet w=10 l=2
+  ad=40 pd=28 as=0 ps=0
M1624 datapath_0/latch_3/latch_one_0[5]/new_latch_0/a_79_32# datapath_0/so5 Vdd Vdd pfet w=10 l=2
+  ad=60 pd=32 as=0 ps=0
M1625 datapath_0/wz5 datapath_0/latch_3/latch_one_0[5]/new_latch_0/a_82_52# datapath_0/latch_3/latch_one_0[5]/new_latch_0/a_99_34# Vdd pfet w=10 l=2
+  ad=0 pd=0 as=0 ps=0
M1626 datapath_0/latch_3/latch_one_0[5]/new_latch_0/a_82_34# datapath_0/latch_3/latch_one_0[5]/new_latch_0/a_79_32# GND GND nfet w=5 l=2
+  ad=20 pd=18 as=0 ps=0
M1627 datapath_0/latch_3/latch_one_0[5]/new_latch_0/a_79_32# datapath_0/so5 GND GND nfet w=5 l=2
+  ad=30 pd=22 as=0 ps=0
M1628 datapath_0/wz5 fsm_0/ros datapath_0/latch_3/latch_one_0[5]/new_latch_0/a_82_34# GND nfet w=5 l=2
+  ad=0 pd=0 as=0 ps=0
M1629 Vdd fsm_0/ros datapath_0/latch_3/latch_one_0[5]/new_latch_0/a_82_52# Vdd pfet w=10 l=2
+  ad=0 pd=0 as=60 ps=32
M1630 GND fsm_0/ros datapath_0/latch_3/latch_one_0[6]/new_latch_0/a_82_52# GND nfet w=5 l=2
+  ad=0 pd=0 as=30 ps=22
M1631 datapath_0/latch_3/latch_one_0[6]/new_latch_0/a_99_34# datapath_0/latch_3/latch_one_0[6]/new_latch_0/a_79_32# Vdd Vdd pfet w=10 l=2
+  ad=40 pd=28 as=0 ps=0
M1632 datapath_0/latch_3/latch_one_0[6]/new_latch_0/a_79_32# datapath_0/so6 Vdd Vdd pfet w=10 l=2
+  ad=60 pd=32 as=0 ps=0
M1633 datapath_0/wz6 datapath_0/latch_3/latch_one_0[6]/new_latch_0/a_82_52# datapath_0/latch_3/latch_one_0[6]/new_latch_0/a_99_34# Vdd pfet w=10 l=2
+  ad=0 pd=0 as=0 ps=0
M1634 datapath_0/latch_3/latch_one_0[6]/new_latch_0/a_82_34# datapath_0/latch_3/latch_one_0[6]/new_latch_0/a_79_32# GND GND nfet w=5 l=2
+  ad=20 pd=18 as=0 ps=0
M1635 datapath_0/latch_3/latch_one_0[6]/new_latch_0/a_79_32# datapath_0/so6 GND GND nfet w=5 l=2
+  ad=30 pd=22 as=0 ps=0
M1636 datapath_0/wz6 fsm_0/ros datapath_0/latch_3/latch_one_0[6]/new_latch_0/a_82_34# GND nfet w=5 l=2
+  ad=0 pd=0 as=0 ps=0
M1637 Vdd fsm_0/ros datapath_0/latch_3/latch_one_0[6]/new_latch_0/a_82_52# Vdd pfet w=10 l=2
+  ad=0 pd=0 as=60 ps=32
M1638 GND fsm_0/ros datapath_0/latch_3/latch_one_0[7]/new_latch_0/a_82_52# GND nfet w=5 l=2
+  ad=0 pd=0 as=30 ps=22
M1639 datapath_0/latch_3/latch_one_0[7]/new_latch_0/a_99_34# datapath_0/latch_3/latch_one_0[7]/new_latch_0/a_79_32# Vdd Vdd pfet w=10 l=2
+  ad=40 pd=28 as=0 ps=0
M1640 datapath_0/latch_3/latch_one_0[7]/new_latch_0/a_79_32# datapath_0/so7 Vdd Vdd pfet w=10 l=2
+  ad=60 pd=32 as=0 ps=0
M1641 datapath_0/wz7 datapath_0/latch_3/latch_one_0[7]/new_latch_0/a_82_52# datapath_0/latch_3/latch_one_0[7]/new_latch_0/a_99_34# Vdd pfet w=10 l=2
+  ad=0 pd=0 as=0 ps=0
M1642 datapath_0/latch_3/latch_one_0[7]/new_latch_0/a_82_34# datapath_0/latch_3/latch_one_0[7]/new_latch_0/a_79_32# GND GND nfet w=5 l=2
+  ad=20 pd=18 as=0 ps=0
M1643 datapath_0/latch_3/latch_one_0[7]/new_latch_0/a_79_32# datapath_0/so7 GND GND nfet w=5 l=2
+  ad=30 pd=22 as=0 ps=0
M1644 datapath_0/wz7 fsm_0/ros datapath_0/latch_3/latch_one_0[7]/new_latch_0/a_82_34# GND nfet w=5 l=2
+  ad=0 pd=0 as=0 ps=0
M1645 Vdd fsm_0/ros datapath_0/latch_3/latch_one_0[7]/new_latch_0/a_82_52# Vdd pfet w=10 l=2
+  ad=0 pd=0 as=60 ps=32
M1646 datapath_0/fblock_0/fblock_one_0[0]/mux2_0/nand2_1/B datapath_0/ry7 GND GND nfet w=5 l=2
+  ad=30 pd=22 as=0 ps=0
M1647 datapath_0/fblock_0/fblock_one_0[0]/mux2_0/nand2_1/B datapath_0/ry7 Vdd Vdd pfet w=10 l=2
+  ad=60 pd=32 as=0 ps=0
M1648 datapath_0/fblock_0/fblock_one_0[0]/mux2_0/nand2_0/a_7_10# datapath_0/ry7 GND GND nfet w=6 l=2
+  ad=42 pd=26 as=0 ps=0
M1649 datapath_0/fblock_0/fblock_one_0[0]/mux2_0/nand2_2/A datapath_0/ry7 Vdd Vdd pfet w=12 l=2
+  ad=84 pd=38 as=0 ps=0
M1650 datapath_0/fblock_0/fblock_one_0[0]/mux2_0/nand2_2/A datapath_0/g2 datapath_0/fblock_0/fblock_one_0[0]/mux2_0/nand2_0/a_7_10# GND nfet w=6 l=2
+  ad=36 pd=24 as=0 ps=0
M1651 Vdd datapath_0/g2 datapath_0/fblock_0/fblock_one_0[0]/mux2_0/nand2_2/A Vdd pfet w=12 l=2
+  ad=0 pd=0 as=0 ps=0
M1652 datapath_0/fblock_0/fblock_one_0[0]/mux2_0/nand2_2/a_7_10# datapath_0/fblock_0/fblock_one_0[0]/mux2_0/nand2_2/A GND GND nfet w=6 l=2
+  ad=42 pd=26 as=0 ps=0
M1653 datapath_0/fblock_0/fblock_one_0[0]/mux2_2/A datapath_0/fblock_0/fblock_one_0[0]/mux2_0/nand2_2/A Vdd Vdd pfet w=12 l=2
+  ad=84 pd=38 as=0 ps=0
M1654 datapath_0/fblock_0/fblock_one_0[0]/mux2_2/A datapath_0/fblock_0/fblock_one_0[0]/mux2_0/nand2_2/B datapath_0/fblock_0/fblock_one_0[0]/mux2_0/nand2_2/a_7_10# GND nfet w=6 l=2
+  ad=36 pd=24 as=0 ps=0
M1655 Vdd datapath_0/fblock_0/fblock_one_0[0]/mux2_0/nand2_2/B datapath_0/fblock_0/fblock_one_0[0]/mux2_2/A Vdd pfet w=12 l=2
+  ad=0 pd=0 as=0 ps=0
M1656 datapath_0/fblock_0/fblock_one_0[0]/mux2_0/nand2_1/a_7_10# GND GND GND nfet w=6 l=2
+  ad=42 pd=26 as=0 ps=0
M1657 datapath_0/fblock_0/fblock_one_0[0]/mux2_0/nand2_2/B GND Vdd Vdd pfet w=12 l=2
+  ad=84 pd=38 as=0 ps=0
M1658 datapath_0/fblock_0/fblock_one_0[0]/mux2_0/nand2_2/B datapath_0/fblock_0/fblock_one_0[0]/mux2_0/nand2_1/B datapath_0/fblock_0/fblock_one_0[0]/mux2_0/nand2_1/a_7_10# GND nfet w=6 l=2
+  ad=36 pd=24 as=0 ps=0
M1659 Vdd datapath_0/fblock_0/fblock_one_0[0]/mux2_0/nand2_1/B datapath_0/fblock_0/fblock_one_0[0]/mux2_0/nand2_2/B Vdd pfet w=12 l=2
+  ad=0 pd=0 as=0 ps=0
M1660 datapath_0/fblock_0/fblock_one_0[0]/mux2_1/nand2_1/B datapath_0/ry7 GND GND nfet w=5 l=2
+  ad=30 pd=22 as=0 ps=0
M1661 datapath_0/fblock_0/fblock_one_0[0]/mux2_1/nand2_1/B datapath_0/ry7 Vdd Vdd pfet w=10 l=2
+  ad=60 pd=32 as=0 ps=0
M1662 datapath_0/fblock_0/fblock_one_0[0]/mux2_1/nand2_0/a_7_10# datapath_0/ry7 GND GND nfet w=6 l=2
+  ad=42 pd=26 as=0 ps=0
M1663 datapath_0/fblock_0/fblock_one_0[0]/mux2_1/nand2_2/A datapath_0/ry7 Vdd Vdd pfet w=12 l=2
+  ad=84 pd=38 as=0 ps=0
M1664 datapath_0/fblock_0/fblock_one_0[0]/mux2_1/nand2_2/A GND datapath_0/fblock_0/fblock_one_0[0]/mux2_1/nand2_0/a_7_10# GND nfet w=6 l=2
+  ad=36 pd=24 as=0 ps=0
M1665 Vdd GND datapath_0/fblock_0/fblock_one_0[0]/mux2_1/nand2_2/A Vdd pfet w=12 l=2
+  ad=0 pd=0 as=0 ps=0
M1666 datapath_0/fblock_0/fblock_one_0[0]/mux2_1/nand2_2/a_7_10# datapath_0/fblock_0/fblock_one_0[0]/mux2_1/nand2_2/A GND GND nfet w=6 l=2
+  ad=42 pd=26 as=0 ps=0
M1667 datapath_0/fblock_0/fblock_one_0[0]/mux2_2/B datapath_0/fblock_0/fblock_one_0[0]/mux2_1/nand2_2/A Vdd Vdd pfet w=12 l=2
+  ad=84 pd=38 as=0 ps=0
M1668 datapath_0/fblock_0/fblock_one_0[0]/mux2_2/B datapath_0/fblock_0/fblock_one_0[0]/mux2_1/nand2_2/B datapath_0/fblock_0/fblock_one_0[0]/mux2_1/nand2_2/a_7_10# GND nfet w=6 l=2
+  ad=36 pd=24 as=0 ps=0
M1669 Vdd datapath_0/fblock_0/fblock_one_0[0]/mux2_1/nand2_2/B datapath_0/fblock_0/fblock_one_0[0]/mux2_2/B Vdd pfet w=12 l=2
+  ad=0 pd=0 as=0 ps=0
M1670 datapath_0/fblock_0/fblock_one_0[0]/mux2_1/nand2_1/a_7_10# datapath_0/g2 GND GND nfet w=6 l=2
+  ad=42 pd=26 as=0 ps=0
M1671 datapath_0/fblock_0/fblock_one_0[0]/mux2_1/nand2_2/B datapath_0/g2 Vdd Vdd pfet w=12 l=2
+  ad=84 pd=38 as=0 ps=0
M1672 datapath_0/fblock_0/fblock_one_0[0]/mux2_1/nand2_2/B datapath_0/fblock_0/fblock_one_0[0]/mux2_1/nand2_1/B datapath_0/fblock_0/fblock_one_0[0]/mux2_1/nand2_1/a_7_10# GND nfet w=6 l=2
+  ad=36 pd=24 as=0 ps=0
M1673 Vdd datapath_0/fblock_0/fblock_one_0[0]/mux2_1/nand2_1/B datapath_0/fblock_0/fblock_one_0[0]/mux2_1/nand2_2/B Vdd pfet w=12 l=2
+  ad=0 pd=0 as=0 ps=0
M1674 datapath_0/fblock_0/fblock_one_0[0]/mux2_2/nand2_1/B datapath_0/rx7 GND GND nfet w=5 l=2
+  ad=30 pd=22 as=0 ps=0
M1675 datapath_0/fblock_0/fblock_one_0[0]/mux2_2/nand2_1/B datapath_0/rx7 Vdd Vdd pfet w=10 l=2
+  ad=60 pd=32 as=0 ps=0
M1676 datapath_0/fblock_0/fblock_one_0[0]/mux2_2/nand2_0/a_7_10# datapath_0/rx7 GND GND nfet w=6 l=2
+  ad=42 pd=26 as=0 ps=0
M1677 datapath_0/fblock_0/fblock_one_0[0]/mux2_2/nand2_2/A datapath_0/rx7 Vdd Vdd pfet w=12 l=2
+  ad=84 pd=38 as=0 ps=0
M1678 datapath_0/fblock_0/fblock_one_0[0]/mux2_2/nand2_2/A datapath_0/fblock_0/fblock_one_0[0]/mux2_2/B datapath_0/fblock_0/fblock_one_0[0]/mux2_2/nand2_0/a_7_10# GND nfet w=6 l=2
+  ad=36 pd=24 as=0 ps=0
M1679 Vdd datapath_0/fblock_0/fblock_one_0[0]/mux2_2/B datapath_0/fblock_0/fblock_one_0[0]/mux2_2/nand2_2/A Vdd pfet w=12 l=2
+  ad=0 pd=0 as=0 ps=0
M1680 datapath_0/fblock_0/fblock_one_0[0]/mux2_2/nand2_2/a_7_10# datapath_0/fblock_0/fblock_one_0[0]/mux2_2/nand2_2/A GND GND nfet w=6 l=2
+  ad=42 pd=26 as=0 ps=0
M1681 datapath_0/latch_1/in7 datapath_0/fblock_0/fblock_one_0[0]/mux2_2/nand2_2/A Vdd Vdd pfet w=12 l=2
+  ad=84 pd=38 as=0 ps=0
M1682 datapath_0/latch_1/in7 datapath_0/fblock_0/fblock_one_0[0]/mux2_2/nand2_2/B datapath_0/fblock_0/fblock_one_0[0]/mux2_2/nand2_2/a_7_10# GND nfet w=6 l=2
+  ad=36 pd=24 as=0 ps=0
M1683 Vdd datapath_0/fblock_0/fblock_one_0[0]/mux2_2/nand2_2/B datapath_0/latch_1/in7 Vdd pfet w=12 l=2
+  ad=0 pd=0 as=0 ps=0
M1684 datapath_0/fblock_0/fblock_one_0[0]/mux2_2/nand2_1/a_7_10# datapath_0/fblock_0/fblock_one_0[0]/mux2_2/A GND GND nfet w=6 l=2
+  ad=42 pd=26 as=0 ps=0
M1685 datapath_0/fblock_0/fblock_one_0[0]/mux2_2/nand2_2/B datapath_0/fblock_0/fblock_one_0[0]/mux2_2/A Vdd Vdd pfet w=12 l=2
+  ad=84 pd=38 as=0 ps=0
M1686 datapath_0/fblock_0/fblock_one_0[0]/mux2_2/nand2_2/B datapath_0/fblock_0/fblock_one_0[0]/mux2_2/nand2_1/B datapath_0/fblock_0/fblock_one_0[0]/mux2_2/nand2_1/a_7_10# GND nfet w=6 l=2
+  ad=36 pd=24 as=0 ps=0
M1687 Vdd datapath_0/fblock_0/fblock_one_0[0]/mux2_2/nand2_1/B datapath_0/fblock_0/fblock_one_0[0]/mux2_2/nand2_2/B Vdd pfet w=12 l=2
+  ad=0 pd=0 as=0 ps=0
M1688 datapath_0/fblock_0/fblock_one_0[1]/mux2_0/nand2_1/B datapath_0/ry6 GND GND nfet w=5 l=2
+  ad=30 pd=22 as=0 ps=0
M1689 datapath_0/fblock_0/fblock_one_0[1]/mux2_0/nand2_1/B datapath_0/ry6 Vdd Vdd pfet w=10 l=2
+  ad=60 pd=32 as=0 ps=0
M1690 datapath_0/fblock_0/fblock_one_0[1]/mux2_0/nand2_0/a_7_10# datapath_0/ry6 GND GND nfet w=6 l=2
+  ad=42 pd=26 as=0 ps=0
M1691 datapath_0/fblock_0/fblock_one_0[1]/mux2_0/nand2_2/A datapath_0/ry6 Vdd Vdd pfet w=12 l=2
+  ad=84 pd=38 as=0 ps=0
M1692 datapath_0/fblock_0/fblock_one_0[1]/mux2_0/nand2_2/A datapath_0/g2 datapath_0/fblock_0/fblock_one_0[1]/mux2_0/nand2_0/a_7_10# GND nfet w=6 l=2
+  ad=36 pd=24 as=0 ps=0
M1693 Vdd datapath_0/g2 datapath_0/fblock_0/fblock_one_0[1]/mux2_0/nand2_2/A Vdd pfet w=12 l=2
+  ad=0 pd=0 as=0 ps=0
M1694 datapath_0/fblock_0/fblock_one_0[1]/mux2_0/nand2_2/a_7_10# datapath_0/fblock_0/fblock_one_0[1]/mux2_0/nand2_2/A GND GND nfet w=6 l=2
+  ad=42 pd=26 as=0 ps=0
M1695 datapath_0/fblock_0/fblock_one_0[1]/mux2_2/A datapath_0/fblock_0/fblock_one_0[1]/mux2_0/nand2_2/A Vdd Vdd pfet w=12 l=2
+  ad=84 pd=38 as=0 ps=0
M1696 datapath_0/fblock_0/fblock_one_0[1]/mux2_2/A datapath_0/fblock_0/fblock_one_0[1]/mux2_0/nand2_2/B datapath_0/fblock_0/fblock_one_0[1]/mux2_0/nand2_2/a_7_10# GND nfet w=6 l=2
+  ad=36 pd=24 as=0 ps=0
M1697 Vdd datapath_0/fblock_0/fblock_one_0[1]/mux2_0/nand2_2/B datapath_0/fblock_0/fblock_one_0[1]/mux2_2/A Vdd pfet w=12 l=2
+  ad=0 pd=0 as=0 ps=0
M1698 datapath_0/fblock_0/fblock_one_0[1]/mux2_0/nand2_1/a_7_10# GND GND GND nfet w=6 l=2
+  ad=42 pd=26 as=0 ps=0
M1699 datapath_0/fblock_0/fblock_one_0[1]/mux2_0/nand2_2/B GND Vdd Vdd pfet w=12 l=2
+  ad=84 pd=38 as=0 ps=0
M1700 datapath_0/fblock_0/fblock_one_0[1]/mux2_0/nand2_2/B datapath_0/fblock_0/fblock_one_0[1]/mux2_0/nand2_1/B datapath_0/fblock_0/fblock_one_0[1]/mux2_0/nand2_1/a_7_10# GND nfet w=6 l=2
+  ad=36 pd=24 as=0 ps=0
M1701 Vdd datapath_0/fblock_0/fblock_one_0[1]/mux2_0/nand2_1/B datapath_0/fblock_0/fblock_one_0[1]/mux2_0/nand2_2/B Vdd pfet w=12 l=2
+  ad=0 pd=0 as=0 ps=0
M1702 datapath_0/fblock_0/fblock_one_0[1]/mux2_1/nand2_1/B datapath_0/ry6 GND GND nfet w=5 l=2
+  ad=30 pd=22 as=0 ps=0
M1703 datapath_0/fblock_0/fblock_one_0[1]/mux2_1/nand2_1/B datapath_0/ry6 Vdd Vdd pfet w=10 l=2
+  ad=60 pd=32 as=0 ps=0
M1704 datapath_0/fblock_0/fblock_one_0[1]/mux2_1/nand2_0/a_7_10# datapath_0/ry6 GND GND nfet w=6 l=2
+  ad=42 pd=26 as=0 ps=0
M1705 datapath_0/fblock_0/fblock_one_0[1]/mux2_1/nand2_2/A datapath_0/ry6 Vdd Vdd pfet w=12 l=2
+  ad=84 pd=38 as=0 ps=0
M1706 datapath_0/fblock_0/fblock_one_0[1]/mux2_1/nand2_2/A GND datapath_0/fblock_0/fblock_one_0[1]/mux2_1/nand2_0/a_7_10# GND nfet w=6 l=2
+  ad=36 pd=24 as=0 ps=0
M1707 Vdd GND datapath_0/fblock_0/fblock_one_0[1]/mux2_1/nand2_2/A Vdd pfet w=12 l=2
+  ad=0 pd=0 as=0 ps=0
M1708 datapath_0/fblock_0/fblock_one_0[1]/mux2_1/nand2_2/a_7_10# datapath_0/fblock_0/fblock_one_0[1]/mux2_1/nand2_2/A GND GND nfet w=6 l=2
+  ad=42 pd=26 as=0 ps=0
M1709 datapath_0/fblock_0/fblock_one_0[1]/mux2_2/B datapath_0/fblock_0/fblock_one_0[1]/mux2_1/nand2_2/A Vdd Vdd pfet w=12 l=2
+  ad=84 pd=38 as=0 ps=0
M1710 datapath_0/fblock_0/fblock_one_0[1]/mux2_2/B datapath_0/fblock_0/fblock_one_0[1]/mux2_1/nand2_2/B datapath_0/fblock_0/fblock_one_0[1]/mux2_1/nand2_2/a_7_10# GND nfet w=6 l=2
+  ad=36 pd=24 as=0 ps=0
M1711 Vdd datapath_0/fblock_0/fblock_one_0[1]/mux2_1/nand2_2/B datapath_0/fblock_0/fblock_one_0[1]/mux2_2/B Vdd pfet w=12 l=2
+  ad=0 pd=0 as=0 ps=0
M1712 datapath_0/fblock_0/fblock_one_0[1]/mux2_1/nand2_1/a_7_10# datapath_0/g2 GND GND nfet w=6 l=2
+  ad=42 pd=26 as=0 ps=0
M1713 datapath_0/fblock_0/fblock_one_0[1]/mux2_1/nand2_2/B datapath_0/g2 Vdd Vdd pfet w=12 l=2
+  ad=84 pd=38 as=0 ps=0
M1714 datapath_0/fblock_0/fblock_one_0[1]/mux2_1/nand2_2/B datapath_0/fblock_0/fblock_one_0[1]/mux2_1/nand2_1/B datapath_0/fblock_0/fblock_one_0[1]/mux2_1/nand2_1/a_7_10# GND nfet w=6 l=2
+  ad=36 pd=24 as=0 ps=0
M1715 Vdd datapath_0/fblock_0/fblock_one_0[1]/mux2_1/nand2_1/B datapath_0/fblock_0/fblock_one_0[1]/mux2_1/nand2_2/B Vdd pfet w=12 l=2
+  ad=0 pd=0 as=0 ps=0
M1716 datapath_0/fblock_0/fblock_one_0[1]/mux2_2/nand2_1/B datapath_0/rx6 GND GND nfet w=5 l=2
+  ad=30 pd=22 as=0 ps=0
M1717 datapath_0/fblock_0/fblock_one_0[1]/mux2_2/nand2_1/B datapath_0/rx6 Vdd Vdd pfet w=10 l=2
+  ad=60 pd=32 as=0 ps=0
M1718 datapath_0/fblock_0/fblock_one_0[1]/mux2_2/nand2_0/a_7_10# datapath_0/rx6 GND GND nfet w=6 l=2
+  ad=42 pd=26 as=0 ps=0
M1719 datapath_0/fblock_0/fblock_one_0[1]/mux2_2/nand2_2/A datapath_0/rx6 Vdd Vdd pfet w=12 l=2
+  ad=84 pd=38 as=0 ps=0
M1720 datapath_0/fblock_0/fblock_one_0[1]/mux2_2/nand2_2/A datapath_0/fblock_0/fblock_one_0[1]/mux2_2/B datapath_0/fblock_0/fblock_one_0[1]/mux2_2/nand2_0/a_7_10# GND nfet w=6 l=2
+  ad=36 pd=24 as=0 ps=0
M1721 Vdd datapath_0/fblock_0/fblock_one_0[1]/mux2_2/B datapath_0/fblock_0/fblock_one_0[1]/mux2_2/nand2_2/A Vdd pfet w=12 l=2
+  ad=0 pd=0 as=0 ps=0
M1722 datapath_0/fblock_0/fblock_one_0[1]/mux2_2/nand2_2/a_7_10# datapath_0/fblock_0/fblock_one_0[1]/mux2_2/nand2_2/A GND GND nfet w=6 l=2
+  ad=42 pd=26 as=0 ps=0
M1723 datapath_0/latch_1/in6 datapath_0/fblock_0/fblock_one_0[1]/mux2_2/nand2_2/A Vdd Vdd pfet w=12 l=2
+  ad=84 pd=38 as=0 ps=0
M1724 datapath_0/latch_1/in6 datapath_0/fblock_0/fblock_one_0[1]/mux2_2/nand2_2/B datapath_0/fblock_0/fblock_one_0[1]/mux2_2/nand2_2/a_7_10# GND nfet w=6 l=2
+  ad=36 pd=24 as=0 ps=0
M1725 Vdd datapath_0/fblock_0/fblock_one_0[1]/mux2_2/nand2_2/B datapath_0/latch_1/in6 Vdd pfet w=12 l=2
+  ad=0 pd=0 as=0 ps=0
M1726 datapath_0/fblock_0/fblock_one_0[1]/mux2_2/nand2_1/a_7_10# datapath_0/fblock_0/fblock_one_0[1]/mux2_2/A GND GND nfet w=6 l=2
+  ad=42 pd=26 as=0 ps=0
M1727 datapath_0/fblock_0/fblock_one_0[1]/mux2_2/nand2_2/B datapath_0/fblock_0/fblock_one_0[1]/mux2_2/A Vdd Vdd pfet w=12 l=2
+  ad=84 pd=38 as=0 ps=0
M1728 datapath_0/fblock_0/fblock_one_0[1]/mux2_2/nand2_2/B datapath_0/fblock_0/fblock_one_0[1]/mux2_2/nand2_1/B datapath_0/fblock_0/fblock_one_0[1]/mux2_2/nand2_1/a_7_10# GND nfet w=6 l=2
+  ad=36 pd=24 as=0 ps=0
M1729 Vdd datapath_0/fblock_0/fblock_one_0[1]/mux2_2/nand2_1/B datapath_0/fblock_0/fblock_one_0[1]/mux2_2/nand2_2/B Vdd pfet w=12 l=2
+  ad=0 pd=0 as=0 ps=0
M1730 datapath_0/fblock_0/fblock_one_0[2]/mux2_0/nand2_1/B datapath_0/ry5 GND GND nfet w=5 l=2
+  ad=30 pd=22 as=0 ps=0
M1731 datapath_0/fblock_0/fblock_one_0[2]/mux2_0/nand2_1/B datapath_0/ry5 Vdd Vdd pfet w=10 l=2
+  ad=60 pd=32 as=0 ps=0
M1732 datapath_0/fblock_0/fblock_one_0[2]/mux2_0/nand2_0/a_7_10# datapath_0/ry5 GND GND nfet w=6 l=2
+  ad=42 pd=26 as=0 ps=0
M1733 datapath_0/fblock_0/fblock_one_0[2]/mux2_0/nand2_2/A datapath_0/ry5 Vdd Vdd pfet w=12 l=2
+  ad=84 pd=38 as=0 ps=0
M1734 datapath_0/fblock_0/fblock_one_0[2]/mux2_0/nand2_2/A datapath_0/g2 datapath_0/fblock_0/fblock_one_0[2]/mux2_0/nand2_0/a_7_10# GND nfet w=6 l=2
+  ad=36 pd=24 as=0 ps=0
M1735 Vdd datapath_0/g2 datapath_0/fblock_0/fblock_one_0[2]/mux2_0/nand2_2/A Vdd pfet w=12 l=2
+  ad=0 pd=0 as=0 ps=0
M1736 datapath_0/fblock_0/fblock_one_0[2]/mux2_0/nand2_2/a_7_10# datapath_0/fblock_0/fblock_one_0[2]/mux2_0/nand2_2/A GND GND nfet w=6 l=2
+  ad=42 pd=26 as=0 ps=0
M1737 datapath_0/fblock_0/fblock_one_0[2]/mux2_2/A datapath_0/fblock_0/fblock_one_0[2]/mux2_0/nand2_2/A Vdd Vdd pfet w=12 l=2
+  ad=84 pd=38 as=0 ps=0
M1738 datapath_0/fblock_0/fblock_one_0[2]/mux2_2/A datapath_0/fblock_0/fblock_one_0[2]/mux2_0/nand2_2/B datapath_0/fblock_0/fblock_one_0[2]/mux2_0/nand2_2/a_7_10# GND nfet w=6 l=2
+  ad=36 pd=24 as=0 ps=0
M1739 Vdd datapath_0/fblock_0/fblock_one_0[2]/mux2_0/nand2_2/B datapath_0/fblock_0/fblock_one_0[2]/mux2_2/A Vdd pfet w=12 l=2
+  ad=0 pd=0 as=0 ps=0
M1740 datapath_0/fblock_0/fblock_one_0[2]/mux2_0/nand2_1/a_7_10# GND GND GND nfet w=6 l=2
+  ad=42 pd=26 as=0 ps=0
M1741 datapath_0/fblock_0/fblock_one_0[2]/mux2_0/nand2_2/B GND Vdd Vdd pfet w=12 l=2
+  ad=84 pd=38 as=0 ps=0
M1742 datapath_0/fblock_0/fblock_one_0[2]/mux2_0/nand2_2/B datapath_0/fblock_0/fblock_one_0[2]/mux2_0/nand2_1/B datapath_0/fblock_0/fblock_one_0[2]/mux2_0/nand2_1/a_7_10# GND nfet w=6 l=2
+  ad=36 pd=24 as=0 ps=0
M1743 Vdd datapath_0/fblock_0/fblock_one_0[2]/mux2_0/nand2_1/B datapath_0/fblock_0/fblock_one_0[2]/mux2_0/nand2_2/B Vdd pfet w=12 l=2
+  ad=0 pd=0 as=0 ps=0
M1744 datapath_0/fblock_0/fblock_one_0[2]/mux2_1/nand2_1/B datapath_0/ry5 GND GND nfet w=5 l=2
+  ad=30 pd=22 as=0 ps=0
M1745 datapath_0/fblock_0/fblock_one_0[2]/mux2_1/nand2_1/B datapath_0/ry5 Vdd Vdd pfet w=10 l=2
+  ad=60 pd=32 as=0 ps=0
M1746 datapath_0/fblock_0/fblock_one_0[2]/mux2_1/nand2_0/a_7_10# datapath_0/ry5 GND GND nfet w=6 l=2
+  ad=42 pd=26 as=0 ps=0
M1747 datapath_0/fblock_0/fblock_one_0[2]/mux2_1/nand2_2/A datapath_0/ry5 Vdd Vdd pfet w=12 l=2
+  ad=84 pd=38 as=0 ps=0
M1748 datapath_0/fblock_0/fblock_one_0[2]/mux2_1/nand2_2/A GND datapath_0/fblock_0/fblock_one_0[2]/mux2_1/nand2_0/a_7_10# GND nfet w=6 l=2
+  ad=36 pd=24 as=0 ps=0
M1749 Vdd GND datapath_0/fblock_0/fblock_one_0[2]/mux2_1/nand2_2/A Vdd pfet w=12 l=2
+  ad=0 pd=0 as=0 ps=0
M1750 datapath_0/fblock_0/fblock_one_0[2]/mux2_1/nand2_2/a_7_10# datapath_0/fblock_0/fblock_one_0[2]/mux2_1/nand2_2/A GND GND nfet w=6 l=2
+  ad=42 pd=26 as=0 ps=0
M1751 datapath_0/fblock_0/fblock_one_0[2]/mux2_2/B datapath_0/fblock_0/fblock_one_0[2]/mux2_1/nand2_2/A Vdd Vdd pfet w=12 l=2
+  ad=84 pd=38 as=0 ps=0
M1752 datapath_0/fblock_0/fblock_one_0[2]/mux2_2/B datapath_0/fblock_0/fblock_one_0[2]/mux2_1/nand2_2/B datapath_0/fblock_0/fblock_one_0[2]/mux2_1/nand2_2/a_7_10# GND nfet w=6 l=2
+  ad=36 pd=24 as=0 ps=0
M1753 Vdd datapath_0/fblock_0/fblock_one_0[2]/mux2_1/nand2_2/B datapath_0/fblock_0/fblock_one_0[2]/mux2_2/B Vdd pfet w=12 l=2
+  ad=0 pd=0 as=0 ps=0
M1754 datapath_0/fblock_0/fblock_one_0[2]/mux2_1/nand2_1/a_7_10# datapath_0/g2 GND GND nfet w=6 l=2
+  ad=42 pd=26 as=0 ps=0
M1755 datapath_0/fblock_0/fblock_one_0[2]/mux2_1/nand2_2/B datapath_0/g2 Vdd Vdd pfet w=12 l=2
+  ad=84 pd=38 as=0 ps=0
M1756 datapath_0/fblock_0/fblock_one_0[2]/mux2_1/nand2_2/B datapath_0/fblock_0/fblock_one_0[2]/mux2_1/nand2_1/B datapath_0/fblock_0/fblock_one_0[2]/mux2_1/nand2_1/a_7_10# GND nfet w=6 l=2
+  ad=36 pd=24 as=0 ps=0
M1757 Vdd datapath_0/fblock_0/fblock_one_0[2]/mux2_1/nand2_1/B datapath_0/fblock_0/fblock_one_0[2]/mux2_1/nand2_2/B Vdd pfet w=12 l=2
+  ad=0 pd=0 as=0 ps=0
M1758 datapath_0/fblock_0/fblock_one_0[2]/mux2_2/nand2_1/B datapath_0/rx5 GND GND nfet w=5 l=2
+  ad=30 pd=22 as=0 ps=0
M1759 datapath_0/fblock_0/fblock_one_0[2]/mux2_2/nand2_1/B datapath_0/rx5 Vdd Vdd pfet w=10 l=2
+  ad=60 pd=32 as=0 ps=0
M1760 datapath_0/fblock_0/fblock_one_0[2]/mux2_2/nand2_0/a_7_10# datapath_0/rx5 GND GND nfet w=6 l=2
+  ad=42 pd=26 as=0 ps=0
M1761 datapath_0/fblock_0/fblock_one_0[2]/mux2_2/nand2_2/A datapath_0/rx5 Vdd Vdd pfet w=12 l=2
+  ad=84 pd=38 as=0 ps=0
M1762 datapath_0/fblock_0/fblock_one_0[2]/mux2_2/nand2_2/A datapath_0/fblock_0/fblock_one_0[2]/mux2_2/B datapath_0/fblock_0/fblock_one_0[2]/mux2_2/nand2_0/a_7_10# GND nfet w=6 l=2
+  ad=36 pd=24 as=0 ps=0
M1763 Vdd datapath_0/fblock_0/fblock_one_0[2]/mux2_2/B datapath_0/fblock_0/fblock_one_0[2]/mux2_2/nand2_2/A Vdd pfet w=12 l=2
+  ad=0 pd=0 as=0 ps=0
M1764 datapath_0/fblock_0/fblock_one_0[2]/mux2_2/nand2_2/a_7_10# datapath_0/fblock_0/fblock_one_0[2]/mux2_2/nand2_2/A GND GND nfet w=6 l=2
+  ad=42 pd=26 as=0 ps=0
M1765 datapath_0/latch_1/in5 datapath_0/fblock_0/fblock_one_0[2]/mux2_2/nand2_2/A Vdd Vdd pfet w=12 l=2
+  ad=84 pd=38 as=0 ps=0
M1766 datapath_0/latch_1/in5 datapath_0/fblock_0/fblock_one_0[2]/mux2_2/nand2_2/B datapath_0/fblock_0/fblock_one_0[2]/mux2_2/nand2_2/a_7_10# GND nfet w=6 l=2
+  ad=36 pd=24 as=0 ps=0
M1767 Vdd datapath_0/fblock_0/fblock_one_0[2]/mux2_2/nand2_2/B datapath_0/latch_1/in5 Vdd pfet w=12 l=2
+  ad=0 pd=0 as=0 ps=0
M1768 datapath_0/fblock_0/fblock_one_0[2]/mux2_2/nand2_1/a_7_10# datapath_0/fblock_0/fblock_one_0[2]/mux2_2/A GND GND nfet w=6 l=2
+  ad=42 pd=26 as=0 ps=0
M1769 datapath_0/fblock_0/fblock_one_0[2]/mux2_2/nand2_2/B datapath_0/fblock_0/fblock_one_0[2]/mux2_2/A Vdd Vdd pfet w=12 l=2
+  ad=84 pd=38 as=0 ps=0
M1770 datapath_0/fblock_0/fblock_one_0[2]/mux2_2/nand2_2/B datapath_0/fblock_0/fblock_one_0[2]/mux2_2/nand2_1/B datapath_0/fblock_0/fblock_one_0[2]/mux2_2/nand2_1/a_7_10# GND nfet w=6 l=2
+  ad=36 pd=24 as=0 ps=0
M1771 Vdd datapath_0/fblock_0/fblock_one_0[2]/mux2_2/nand2_1/B datapath_0/fblock_0/fblock_one_0[2]/mux2_2/nand2_2/B Vdd pfet w=12 l=2
+  ad=0 pd=0 as=0 ps=0
M1772 datapath_0/fblock_0/fblock_one_0[3]/mux2_0/nand2_1/B datapath_0/ry4 GND GND nfet w=5 l=2
+  ad=30 pd=22 as=0 ps=0
M1773 datapath_0/fblock_0/fblock_one_0[3]/mux2_0/nand2_1/B datapath_0/ry4 Vdd Vdd pfet w=10 l=2
+  ad=60 pd=32 as=0 ps=0
M1774 datapath_0/fblock_0/fblock_one_0[3]/mux2_0/nand2_0/a_7_10# datapath_0/ry4 GND GND nfet w=6 l=2
+  ad=42 pd=26 as=0 ps=0
M1775 datapath_0/fblock_0/fblock_one_0[3]/mux2_0/nand2_2/A datapath_0/ry4 Vdd Vdd pfet w=12 l=2
+  ad=84 pd=38 as=0 ps=0
M1776 datapath_0/fblock_0/fblock_one_0[3]/mux2_0/nand2_2/A datapath_0/g2 datapath_0/fblock_0/fblock_one_0[3]/mux2_0/nand2_0/a_7_10# GND nfet w=6 l=2
+  ad=36 pd=24 as=0 ps=0
M1777 Vdd datapath_0/g2 datapath_0/fblock_0/fblock_one_0[3]/mux2_0/nand2_2/A Vdd pfet w=12 l=2
+  ad=0 pd=0 as=0 ps=0
M1778 datapath_0/fblock_0/fblock_one_0[3]/mux2_0/nand2_2/a_7_10# datapath_0/fblock_0/fblock_one_0[3]/mux2_0/nand2_2/A GND GND nfet w=6 l=2
+  ad=42 pd=26 as=0 ps=0
M1779 datapath_0/fblock_0/fblock_one_0[3]/mux2_2/A datapath_0/fblock_0/fblock_one_0[3]/mux2_0/nand2_2/A Vdd Vdd pfet w=12 l=2
+  ad=84 pd=38 as=0 ps=0
M1780 datapath_0/fblock_0/fblock_one_0[3]/mux2_2/A datapath_0/fblock_0/fblock_one_0[3]/mux2_0/nand2_2/B datapath_0/fblock_0/fblock_one_0[3]/mux2_0/nand2_2/a_7_10# GND nfet w=6 l=2
+  ad=36 pd=24 as=0 ps=0
M1781 Vdd datapath_0/fblock_0/fblock_one_0[3]/mux2_0/nand2_2/B datapath_0/fblock_0/fblock_one_0[3]/mux2_2/A Vdd pfet w=12 l=2
+  ad=0 pd=0 as=0 ps=0
M1782 datapath_0/fblock_0/fblock_one_0[3]/mux2_0/nand2_1/a_7_10# GND GND GND nfet w=6 l=2
+  ad=42 pd=26 as=0 ps=0
M1783 datapath_0/fblock_0/fblock_one_0[3]/mux2_0/nand2_2/B GND Vdd Vdd pfet w=12 l=2
+  ad=84 pd=38 as=0 ps=0
M1784 datapath_0/fblock_0/fblock_one_0[3]/mux2_0/nand2_2/B datapath_0/fblock_0/fblock_one_0[3]/mux2_0/nand2_1/B datapath_0/fblock_0/fblock_one_0[3]/mux2_0/nand2_1/a_7_10# GND nfet w=6 l=2
+  ad=36 pd=24 as=0 ps=0
M1785 Vdd datapath_0/fblock_0/fblock_one_0[3]/mux2_0/nand2_1/B datapath_0/fblock_0/fblock_one_0[3]/mux2_0/nand2_2/B Vdd pfet w=12 l=2
+  ad=0 pd=0 as=0 ps=0
M1786 datapath_0/fblock_0/fblock_one_0[3]/mux2_1/nand2_1/B datapath_0/ry4 GND GND nfet w=5 l=2
+  ad=30 pd=22 as=0 ps=0
M1787 datapath_0/fblock_0/fblock_one_0[3]/mux2_1/nand2_1/B datapath_0/ry4 Vdd Vdd pfet w=10 l=2
+  ad=60 pd=32 as=0 ps=0
M1788 datapath_0/fblock_0/fblock_one_0[3]/mux2_1/nand2_0/a_7_10# datapath_0/ry4 GND GND nfet w=6 l=2
+  ad=42 pd=26 as=0 ps=0
M1789 datapath_0/fblock_0/fblock_one_0[3]/mux2_1/nand2_2/A datapath_0/ry4 Vdd Vdd pfet w=12 l=2
+  ad=84 pd=38 as=0 ps=0
M1790 datapath_0/fblock_0/fblock_one_0[3]/mux2_1/nand2_2/A GND datapath_0/fblock_0/fblock_one_0[3]/mux2_1/nand2_0/a_7_10# GND nfet w=6 l=2
+  ad=36 pd=24 as=0 ps=0
M1791 Vdd GND datapath_0/fblock_0/fblock_one_0[3]/mux2_1/nand2_2/A Vdd pfet w=12 l=2
+  ad=0 pd=0 as=0 ps=0
M1792 datapath_0/fblock_0/fblock_one_0[3]/mux2_1/nand2_2/a_7_10# datapath_0/fblock_0/fblock_one_0[3]/mux2_1/nand2_2/A GND GND nfet w=6 l=2
+  ad=42 pd=26 as=0 ps=0
M1793 datapath_0/fblock_0/fblock_one_0[3]/mux2_2/B datapath_0/fblock_0/fblock_one_0[3]/mux2_1/nand2_2/A Vdd Vdd pfet w=12 l=2
+  ad=84 pd=38 as=0 ps=0
M1794 datapath_0/fblock_0/fblock_one_0[3]/mux2_2/B datapath_0/fblock_0/fblock_one_0[3]/mux2_1/nand2_2/B datapath_0/fblock_0/fblock_one_0[3]/mux2_1/nand2_2/a_7_10# GND nfet w=6 l=2
+  ad=36 pd=24 as=0 ps=0
M1795 Vdd datapath_0/fblock_0/fblock_one_0[3]/mux2_1/nand2_2/B datapath_0/fblock_0/fblock_one_0[3]/mux2_2/B Vdd pfet w=12 l=2
+  ad=0 pd=0 as=0 ps=0
M1796 datapath_0/fblock_0/fblock_one_0[3]/mux2_1/nand2_1/a_7_10# datapath_0/g2 GND GND nfet w=6 l=2
+  ad=42 pd=26 as=0 ps=0
M1797 datapath_0/fblock_0/fblock_one_0[3]/mux2_1/nand2_2/B datapath_0/g2 Vdd Vdd pfet w=12 l=2
+  ad=84 pd=38 as=0 ps=0
M1798 datapath_0/fblock_0/fblock_one_0[3]/mux2_1/nand2_2/B datapath_0/fblock_0/fblock_one_0[3]/mux2_1/nand2_1/B datapath_0/fblock_0/fblock_one_0[3]/mux2_1/nand2_1/a_7_10# GND nfet w=6 l=2
+  ad=36 pd=24 as=0 ps=0
M1799 Vdd datapath_0/fblock_0/fblock_one_0[3]/mux2_1/nand2_1/B datapath_0/fblock_0/fblock_one_0[3]/mux2_1/nand2_2/B Vdd pfet w=12 l=2
+  ad=0 pd=0 as=0 ps=0
M1800 datapath_0/fblock_0/fblock_one_0[3]/mux2_2/nand2_1/B datapath_0/rx4 GND GND nfet w=5 l=2
+  ad=30 pd=22 as=0 ps=0
M1801 datapath_0/fblock_0/fblock_one_0[3]/mux2_2/nand2_1/B datapath_0/rx4 Vdd Vdd pfet w=10 l=2
+  ad=60 pd=32 as=0 ps=0
M1802 datapath_0/fblock_0/fblock_one_0[3]/mux2_2/nand2_0/a_7_10# datapath_0/rx4 GND GND nfet w=6 l=2
+  ad=42 pd=26 as=0 ps=0
M1803 datapath_0/fblock_0/fblock_one_0[3]/mux2_2/nand2_2/A datapath_0/rx4 Vdd Vdd pfet w=12 l=2
+  ad=84 pd=38 as=0 ps=0
M1804 datapath_0/fblock_0/fblock_one_0[3]/mux2_2/nand2_2/A datapath_0/fblock_0/fblock_one_0[3]/mux2_2/B datapath_0/fblock_0/fblock_one_0[3]/mux2_2/nand2_0/a_7_10# GND nfet w=6 l=2
+  ad=36 pd=24 as=0 ps=0
M1805 Vdd datapath_0/fblock_0/fblock_one_0[3]/mux2_2/B datapath_0/fblock_0/fblock_one_0[3]/mux2_2/nand2_2/A Vdd pfet w=12 l=2
+  ad=0 pd=0 as=0 ps=0
M1806 datapath_0/fblock_0/fblock_one_0[3]/mux2_2/nand2_2/a_7_10# datapath_0/fblock_0/fblock_one_0[3]/mux2_2/nand2_2/A GND GND nfet w=6 l=2
+  ad=42 pd=26 as=0 ps=0
M1807 datapath_0/latch_1/in4 datapath_0/fblock_0/fblock_one_0[3]/mux2_2/nand2_2/A Vdd Vdd pfet w=12 l=2
+  ad=84 pd=38 as=0 ps=0
M1808 datapath_0/latch_1/in4 datapath_0/fblock_0/fblock_one_0[3]/mux2_2/nand2_2/B datapath_0/fblock_0/fblock_one_0[3]/mux2_2/nand2_2/a_7_10# GND nfet w=6 l=2
+  ad=36 pd=24 as=0 ps=0
M1809 Vdd datapath_0/fblock_0/fblock_one_0[3]/mux2_2/nand2_2/B datapath_0/latch_1/in4 Vdd pfet w=12 l=2
+  ad=0 pd=0 as=0 ps=0
M1810 datapath_0/fblock_0/fblock_one_0[3]/mux2_2/nand2_1/a_7_10# datapath_0/fblock_0/fblock_one_0[3]/mux2_2/A GND GND nfet w=6 l=2
+  ad=42 pd=26 as=0 ps=0
M1811 datapath_0/fblock_0/fblock_one_0[3]/mux2_2/nand2_2/B datapath_0/fblock_0/fblock_one_0[3]/mux2_2/A Vdd Vdd pfet w=12 l=2
+  ad=84 pd=38 as=0 ps=0
M1812 datapath_0/fblock_0/fblock_one_0[3]/mux2_2/nand2_2/B datapath_0/fblock_0/fblock_one_0[3]/mux2_2/nand2_1/B datapath_0/fblock_0/fblock_one_0[3]/mux2_2/nand2_1/a_7_10# GND nfet w=6 l=2
+  ad=36 pd=24 as=0 ps=0
M1813 Vdd datapath_0/fblock_0/fblock_one_0[3]/mux2_2/nand2_1/B datapath_0/fblock_0/fblock_one_0[3]/mux2_2/nand2_2/B Vdd pfet w=12 l=2
+  ad=0 pd=0 as=0 ps=0
M1814 datapath_0/fblock_0/fblock_one_0[4]/mux2_0/nand2_1/B datapath_0/ry3 GND GND nfet w=5 l=2
+  ad=30 pd=22 as=0 ps=0
M1815 datapath_0/fblock_0/fblock_one_0[4]/mux2_0/nand2_1/B datapath_0/ry3 Vdd Vdd pfet w=10 l=2
+  ad=60 pd=32 as=0 ps=0
M1816 datapath_0/fblock_0/fblock_one_0[4]/mux2_0/nand2_0/a_7_10# datapath_0/ry3 GND GND nfet w=6 l=2
+  ad=42 pd=26 as=0 ps=0
M1817 datapath_0/fblock_0/fblock_one_0[4]/mux2_0/nand2_2/A datapath_0/ry3 Vdd Vdd pfet w=12 l=2
+  ad=84 pd=38 as=0 ps=0
M1818 datapath_0/fblock_0/fblock_one_0[4]/mux2_0/nand2_2/A datapath_0/g2 datapath_0/fblock_0/fblock_one_0[4]/mux2_0/nand2_0/a_7_10# GND nfet w=6 l=2
+  ad=36 pd=24 as=0 ps=0
M1819 Vdd datapath_0/g2 datapath_0/fblock_0/fblock_one_0[4]/mux2_0/nand2_2/A Vdd pfet w=12 l=2
+  ad=0 pd=0 as=0 ps=0
M1820 datapath_0/fblock_0/fblock_one_0[4]/mux2_0/nand2_2/a_7_10# datapath_0/fblock_0/fblock_one_0[4]/mux2_0/nand2_2/A GND GND nfet w=6 l=2
+  ad=42 pd=26 as=0 ps=0
M1821 datapath_0/fblock_0/fblock_one_0[4]/mux2_2/A datapath_0/fblock_0/fblock_one_0[4]/mux2_0/nand2_2/A Vdd Vdd pfet w=12 l=2
+  ad=84 pd=38 as=0 ps=0
M1822 datapath_0/fblock_0/fblock_one_0[4]/mux2_2/A datapath_0/fblock_0/fblock_one_0[4]/mux2_0/nand2_2/B datapath_0/fblock_0/fblock_one_0[4]/mux2_0/nand2_2/a_7_10# GND nfet w=6 l=2
+  ad=36 pd=24 as=0 ps=0
M1823 Vdd datapath_0/fblock_0/fblock_one_0[4]/mux2_0/nand2_2/B datapath_0/fblock_0/fblock_one_0[4]/mux2_2/A Vdd pfet w=12 l=2
+  ad=0 pd=0 as=0 ps=0
M1824 datapath_0/fblock_0/fblock_one_0[4]/mux2_0/nand2_1/a_7_10# GND GND GND nfet w=6 l=2
+  ad=42 pd=26 as=0 ps=0
M1825 datapath_0/fblock_0/fblock_one_0[4]/mux2_0/nand2_2/B GND Vdd Vdd pfet w=12 l=2
+  ad=84 pd=38 as=0 ps=0
M1826 datapath_0/fblock_0/fblock_one_0[4]/mux2_0/nand2_2/B datapath_0/fblock_0/fblock_one_0[4]/mux2_0/nand2_1/B datapath_0/fblock_0/fblock_one_0[4]/mux2_0/nand2_1/a_7_10# GND nfet w=6 l=2
+  ad=36 pd=24 as=0 ps=0
M1827 Vdd datapath_0/fblock_0/fblock_one_0[4]/mux2_0/nand2_1/B datapath_0/fblock_0/fblock_one_0[4]/mux2_0/nand2_2/B Vdd pfet w=12 l=2
+  ad=0 pd=0 as=0 ps=0
M1828 datapath_0/fblock_0/fblock_one_0[4]/mux2_1/nand2_1/B datapath_0/ry3 GND GND nfet w=5 l=2
+  ad=30 pd=22 as=0 ps=0
M1829 datapath_0/fblock_0/fblock_one_0[4]/mux2_1/nand2_1/B datapath_0/ry3 Vdd Vdd pfet w=10 l=2
+  ad=60 pd=32 as=0 ps=0
M1830 datapath_0/fblock_0/fblock_one_0[4]/mux2_1/nand2_0/a_7_10# datapath_0/ry3 GND GND nfet w=6 l=2
+  ad=42 pd=26 as=0 ps=0
M1831 datapath_0/fblock_0/fblock_one_0[4]/mux2_1/nand2_2/A datapath_0/ry3 Vdd Vdd pfet w=12 l=2
+  ad=84 pd=38 as=0 ps=0
M1832 datapath_0/fblock_0/fblock_one_0[4]/mux2_1/nand2_2/A GND datapath_0/fblock_0/fblock_one_0[4]/mux2_1/nand2_0/a_7_10# GND nfet w=6 l=2
+  ad=36 pd=24 as=0 ps=0
M1833 Vdd GND datapath_0/fblock_0/fblock_one_0[4]/mux2_1/nand2_2/A Vdd pfet w=12 l=2
+  ad=0 pd=0 as=0 ps=0
M1834 datapath_0/fblock_0/fblock_one_0[4]/mux2_1/nand2_2/a_7_10# datapath_0/fblock_0/fblock_one_0[4]/mux2_1/nand2_2/A GND GND nfet w=6 l=2
+  ad=42 pd=26 as=0 ps=0
M1835 datapath_0/fblock_0/fblock_one_0[4]/mux2_2/B datapath_0/fblock_0/fblock_one_0[4]/mux2_1/nand2_2/A Vdd Vdd pfet w=12 l=2
+  ad=84 pd=38 as=0 ps=0
M1836 datapath_0/fblock_0/fblock_one_0[4]/mux2_2/B datapath_0/fblock_0/fblock_one_0[4]/mux2_1/nand2_2/B datapath_0/fblock_0/fblock_one_0[4]/mux2_1/nand2_2/a_7_10# GND nfet w=6 l=2
+  ad=36 pd=24 as=0 ps=0
M1837 Vdd datapath_0/fblock_0/fblock_one_0[4]/mux2_1/nand2_2/B datapath_0/fblock_0/fblock_one_0[4]/mux2_2/B Vdd pfet w=12 l=2
+  ad=0 pd=0 as=0 ps=0
M1838 datapath_0/fblock_0/fblock_one_0[4]/mux2_1/nand2_1/a_7_10# datapath_0/g2 GND GND nfet w=6 l=2
+  ad=42 pd=26 as=0 ps=0
M1839 datapath_0/fblock_0/fblock_one_0[4]/mux2_1/nand2_2/B datapath_0/g2 Vdd Vdd pfet w=12 l=2
+  ad=84 pd=38 as=0 ps=0
M1840 datapath_0/fblock_0/fblock_one_0[4]/mux2_1/nand2_2/B datapath_0/fblock_0/fblock_one_0[4]/mux2_1/nand2_1/B datapath_0/fblock_0/fblock_one_0[4]/mux2_1/nand2_1/a_7_10# GND nfet w=6 l=2
+  ad=36 pd=24 as=0 ps=0
M1841 Vdd datapath_0/fblock_0/fblock_one_0[4]/mux2_1/nand2_1/B datapath_0/fblock_0/fblock_one_0[4]/mux2_1/nand2_2/B Vdd pfet w=12 l=2
+  ad=0 pd=0 as=0 ps=0
M1842 datapath_0/fblock_0/fblock_one_0[4]/mux2_2/nand2_1/B datapath_0/rx3 GND GND nfet w=5 l=2
+  ad=30 pd=22 as=0 ps=0
M1843 datapath_0/fblock_0/fblock_one_0[4]/mux2_2/nand2_1/B datapath_0/rx3 Vdd Vdd pfet w=10 l=2
+  ad=60 pd=32 as=0 ps=0
M1844 datapath_0/fblock_0/fblock_one_0[4]/mux2_2/nand2_0/a_7_10# datapath_0/rx3 GND GND nfet w=6 l=2
+  ad=42 pd=26 as=0 ps=0
M1845 datapath_0/fblock_0/fblock_one_0[4]/mux2_2/nand2_2/A datapath_0/rx3 Vdd Vdd pfet w=12 l=2
+  ad=84 pd=38 as=0 ps=0
M1846 datapath_0/fblock_0/fblock_one_0[4]/mux2_2/nand2_2/A datapath_0/fblock_0/fblock_one_0[4]/mux2_2/B datapath_0/fblock_0/fblock_one_0[4]/mux2_2/nand2_0/a_7_10# GND nfet w=6 l=2
+  ad=36 pd=24 as=0 ps=0
M1847 Vdd datapath_0/fblock_0/fblock_one_0[4]/mux2_2/B datapath_0/fblock_0/fblock_one_0[4]/mux2_2/nand2_2/A Vdd pfet w=12 l=2
+  ad=0 pd=0 as=0 ps=0
M1848 datapath_0/fblock_0/fblock_one_0[4]/mux2_2/nand2_2/a_7_10# datapath_0/fblock_0/fblock_one_0[4]/mux2_2/nand2_2/A GND GND nfet w=6 l=2
+  ad=42 pd=26 as=0 ps=0
M1849 datapath_0/latch_1/in3 datapath_0/fblock_0/fblock_one_0[4]/mux2_2/nand2_2/A Vdd Vdd pfet w=12 l=2
+  ad=84 pd=38 as=0 ps=0
M1850 datapath_0/latch_1/in3 datapath_0/fblock_0/fblock_one_0[4]/mux2_2/nand2_2/B datapath_0/fblock_0/fblock_one_0[4]/mux2_2/nand2_2/a_7_10# GND nfet w=6 l=2
+  ad=36 pd=24 as=0 ps=0
M1851 Vdd datapath_0/fblock_0/fblock_one_0[4]/mux2_2/nand2_2/B datapath_0/latch_1/in3 Vdd pfet w=12 l=2
+  ad=0 pd=0 as=0 ps=0
M1852 datapath_0/fblock_0/fblock_one_0[4]/mux2_2/nand2_1/a_7_10# datapath_0/fblock_0/fblock_one_0[4]/mux2_2/A GND GND nfet w=6 l=2
+  ad=42 pd=26 as=0 ps=0
M1853 datapath_0/fblock_0/fblock_one_0[4]/mux2_2/nand2_2/B datapath_0/fblock_0/fblock_one_0[4]/mux2_2/A Vdd Vdd pfet w=12 l=2
+  ad=84 pd=38 as=0 ps=0
M1854 datapath_0/fblock_0/fblock_one_0[4]/mux2_2/nand2_2/B datapath_0/fblock_0/fblock_one_0[4]/mux2_2/nand2_1/B datapath_0/fblock_0/fblock_one_0[4]/mux2_2/nand2_1/a_7_10# GND nfet w=6 l=2
+  ad=36 pd=24 as=0 ps=0
M1855 Vdd datapath_0/fblock_0/fblock_one_0[4]/mux2_2/nand2_1/B datapath_0/fblock_0/fblock_one_0[4]/mux2_2/nand2_2/B Vdd pfet w=12 l=2
+  ad=0 pd=0 as=0 ps=0
M1856 datapath_0/fblock_0/fblock_one_0[5]/mux2_0/nand2_1/B datapath_0/ry2 GND GND nfet w=5 l=2
+  ad=30 pd=22 as=0 ps=0
M1857 datapath_0/fblock_0/fblock_one_0[5]/mux2_0/nand2_1/B datapath_0/ry2 Vdd Vdd pfet w=10 l=2
+  ad=60 pd=32 as=0 ps=0
M1858 datapath_0/fblock_0/fblock_one_0[5]/mux2_0/nand2_0/a_7_10# datapath_0/ry2 GND GND nfet w=6 l=2
+  ad=42 pd=26 as=0 ps=0
M1859 datapath_0/fblock_0/fblock_one_0[5]/mux2_0/nand2_2/A datapath_0/ry2 Vdd Vdd pfet w=12 l=2
+  ad=84 pd=38 as=0 ps=0
M1860 datapath_0/fblock_0/fblock_one_0[5]/mux2_0/nand2_2/A datapath_0/g2 datapath_0/fblock_0/fblock_one_0[5]/mux2_0/nand2_0/a_7_10# GND nfet w=6 l=2
+  ad=36 pd=24 as=0 ps=0
M1861 Vdd datapath_0/g2 datapath_0/fblock_0/fblock_one_0[5]/mux2_0/nand2_2/A Vdd pfet w=12 l=2
+  ad=0 pd=0 as=0 ps=0
M1862 datapath_0/fblock_0/fblock_one_0[5]/mux2_0/nand2_2/a_7_10# datapath_0/fblock_0/fblock_one_0[5]/mux2_0/nand2_2/A GND GND nfet w=6 l=2
+  ad=42 pd=26 as=0 ps=0
M1863 datapath_0/fblock_0/fblock_one_0[5]/mux2_2/A datapath_0/fblock_0/fblock_one_0[5]/mux2_0/nand2_2/A Vdd Vdd pfet w=12 l=2
+  ad=84 pd=38 as=0 ps=0
M1864 datapath_0/fblock_0/fblock_one_0[5]/mux2_2/A datapath_0/fblock_0/fblock_one_0[5]/mux2_0/nand2_2/B datapath_0/fblock_0/fblock_one_0[5]/mux2_0/nand2_2/a_7_10# GND nfet w=6 l=2
+  ad=36 pd=24 as=0 ps=0
M1865 Vdd datapath_0/fblock_0/fblock_one_0[5]/mux2_0/nand2_2/B datapath_0/fblock_0/fblock_one_0[5]/mux2_2/A Vdd pfet w=12 l=2
+  ad=0 pd=0 as=0 ps=0
M1866 datapath_0/fblock_0/fblock_one_0[5]/mux2_0/nand2_1/a_7_10# GND GND GND nfet w=6 l=2
+  ad=42 pd=26 as=0 ps=0
M1867 datapath_0/fblock_0/fblock_one_0[5]/mux2_0/nand2_2/B GND Vdd Vdd pfet w=12 l=2
+  ad=84 pd=38 as=0 ps=0
M1868 datapath_0/fblock_0/fblock_one_0[5]/mux2_0/nand2_2/B datapath_0/fblock_0/fblock_one_0[5]/mux2_0/nand2_1/B datapath_0/fblock_0/fblock_one_0[5]/mux2_0/nand2_1/a_7_10# GND nfet w=6 l=2
+  ad=36 pd=24 as=0 ps=0
M1869 Vdd datapath_0/fblock_0/fblock_one_0[5]/mux2_0/nand2_1/B datapath_0/fblock_0/fblock_one_0[5]/mux2_0/nand2_2/B Vdd pfet w=12 l=2
+  ad=0 pd=0 as=0 ps=0
M1870 datapath_0/fblock_0/fblock_one_0[5]/mux2_1/nand2_1/B datapath_0/ry2 GND GND nfet w=5 l=2
+  ad=30 pd=22 as=0 ps=0
M1871 datapath_0/fblock_0/fblock_one_0[5]/mux2_1/nand2_1/B datapath_0/ry2 Vdd Vdd pfet w=10 l=2
+  ad=60 pd=32 as=0 ps=0
M1872 datapath_0/fblock_0/fblock_one_0[5]/mux2_1/nand2_0/a_7_10# datapath_0/ry2 GND GND nfet w=6 l=2
+  ad=42 pd=26 as=0 ps=0
M1873 datapath_0/fblock_0/fblock_one_0[5]/mux2_1/nand2_2/A datapath_0/ry2 Vdd Vdd pfet w=12 l=2
+  ad=84 pd=38 as=0 ps=0
M1874 datapath_0/fblock_0/fblock_one_0[5]/mux2_1/nand2_2/A GND datapath_0/fblock_0/fblock_one_0[5]/mux2_1/nand2_0/a_7_10# GND nfet w=6 l=2
+  ad=36 pd=24 as=0 ps=0
M1875 Vdd GND datapath_0/fblock_0/fblock_one_0[5]/mux2_1/nand2_2/A Vdd pfet w=12 l=2
+  ad=0 pd=0 as=0 ps=0
M1876 datapath_0/fblock_0/fblock_one_0[5]/mux2_1/nand2_2/a_7_10# datapath_0/fblock_0/fblock_one_0[5]/mux2_1/nand2_2/A GND GND nfet w=6 l=2
+  ad=42 pd=26 as=0 ps=0
M1877 datapath_0/fblock_0/fblock_one_0[5]/mux2_2/B datapath_0/fblock_0/fblock_one_0[5]/mux2_1/nand2_2/A Vdd Vdd pfet w=12 l=2
+  ad=84 pd=38 as=0 ps=0
M1878 datapath_0/fblock_0/fblock_one_0[5]/mux2_2/B datapath_0/fblock_0/fblock_one_0[5]/mux2_1/nand2_2/B datapath_0/fblock_0/fblock_one_0[5]/mux2_1/nand2_2/a_7_10# GND nfet w=6 l=2
+  ad=36 pd=24 as=0 ps=0
M1879 Vdd datapath_0/fblock_0/fblock_one_0[5]/mux2_1/nand2_2/B datapath_0/fblock_0/fblock_one_0[5]/mux2_2/B Vdd pfet w=12 l=2
+  ad=0 pd=0 as=0 ps=0
M1880 datapath_0/fblock_0/fblock_one_0[5]/mux2_1/nand2_1/a_7_10# datapath_0/g2 GND GND nfet w=6 l=2
+  ad=42 pd=26 as=0 ps=0
M1881 datapath_0/fblock_0/fblock_one_0[5]/mux2_1/nand2_2/B datapath_0/g2 Vdd Vdd pfet w=12 l=2
+  ad=84 pd=38 as=0 ps=0
M1882 datapath_0/fblock_0/fblock_one_0[5]/mux2_1/nand2_2/B datapath_0/fblock_0/fblock_one_0[5]/mux2_1/nand2_1/B datapath_0/fblock_0/fblock_one_0[5]/mux2_1/nand2_1/a_7_10# GND nfet w=6 l=2
+  ad=36 pd=24 as=0 ps=0
M1883 Vdd datapath_0/fblock_0/fblock_one_0[5]/mux2_1/nand2_1/B datapath_0/fblock_0/fblock_one_0[5]/mux2_1/nand2_2/B Vdd pfet w=12 l=2
+  ad=0 pd=0 as=0 ps=0
M1884 datapath_0/fblock_0/fblock_one_0[5]/mux2_2/nand2_1/B datapath_0/rx2 GND GND nfet w=5 l=2
+  ad=30 pd=22 as=0 ps=0
M1885 datapath_0/fblock_0/fblock_one_0[5]/mux2_2/nand2_1/B datapath_0/rx2 Vdd Vdd pfet w=10 l=2
+  ad=60 pd=32 as=0 ps=0
M1886 datapath_0/fblock_0/fblock_one_0[5]/mux2_2/nand2_0/a_7_10# datapath_0/rx2 GND GND nfet w=6 l=2
+  ad=42 pd=26 as=0 ps=0
M1887 datapath_0/fblock_0/fblock_one_0[5]/mux2_2/nand2_2/A datapath_0/rx2 Vdd Vdd pfet w=12 l=2
+  ad=84 pd=38 as=0 ps=0
M1888 datapath_0/fblock_0/fblock_one_0[5]/mux2_2/nand2_2/A datapath_0/fblock_0/fblock_one_0[5]/mux2_2/B datapath_0/fblock_0/fblock_one_0[5]/mux2_2/nand2_0/a_7_10# GND nfet w=6 l=2
+  ad=36 pd=24 as=0 ps=0
M1889 Vdd datapath_0/fblock_0/fblock_one_0[5]/mux2_2/B datapath_0/fblock_0/fblock_one_0[5]/mux2_2/nand2_2/A Vdd pfet w=12 l=2
+  ad=0 pd=0 as=0 ps=0
M1890 datapath_0/fblock_0/fblock_one_0[5]/mux2_2/nand2_2/a_7_10# datapath_0/fblock_0/fblock_one_0[5]/mux2_2/nand2_2/A GND GND nfet w=6 l=2
+  ad=42 pd=26 as=0 ps=0
M1891 datapath_0/latch_1/in2 datapath_0/fblock_0/fblock_one_0[5]/mux2_2/nand2_2/A Vdd Vdd pfet w=12 l=2
+  ad=84 pd=38 as=0 ps=0
M1892 datapath_0/latch_1/in2 datapath_0/fblock_0/fblock_one_0[5]/mux2_2/nand2_2/B datapath_0/fblock_0/fblock_one_0[5]/mux2_2/nand2_2/a_7_10# GND nfet w=6 l=2
+  ad=36 pd=24 as=0 ps=0
M1893 Vdd datapath_0/fblock_0/fblock_one_0[5]/mux2_2/nand2_2/B datapath_0/latch_1/in2 Vdd pfet w=12 l=2
+  ad=0 pd=0 as=0 ps=0
M1894 datapath_0/fblock_0/fblock_one_0[5]/mux2_2/nand2_1/a_7_10# datapath_0/fblock_0/fblock_one_0[5]/mux2_2/A GND GND nfet w=6 l=2
+  ad=42 pd=26 as=0 ps=0
M1895 datapath_0/fblock_0/fblock_one_0[5]/mux2_2/nand2_2/B datapath_0/fblock_0/fblock_one_0[5]/mux2_2/A Vdd Vdd pfet w=12 l=2
+  ad=84 pd=38 as=0 ps=0
M1896 datapath_0/fblock_0/fblock_one_0[5]/mux2_2/nand2_2/B datapath_0/fblock_0/fblock_one_0[5]/mux2_2/nand2_1/B datapath_0/fblock_0/fblock_one_0[5]/mux2_2/nand2_1/a_7_10# GND nfet w=6 l=2
+  ad=36 pd=24 as=0 ps=0
M1897 Vdd datapath_0/fblock_0/fblock_one_0[5]/mux2_2/nand2_1/B datapath_0/fblock_0/fblock_one_0[5]/mux2_2/nand2_2/B Vdd pfet w=12 l=2
+  ad=0 pd=0 as=0 ps=0
M1898 datapath_0/fblock_0/fblock_one_0[6]/mux2_0/nand2_1/B datapath_0/ry1 GND GND nfet w=5 l=2
+  ad=30 pd=22 as=0 ps=0
M1899 datapath_0/fblock_0/fblock_one_0[6]/mux2_0/nand2_1/B datapath_0/ry1 Vdd Vdd pfet w=10 l=2
+  ad=60 pd=32 as=0 ps=0
M1900 datapath_0/fblock_0/fblock_one_0[6]/mux2_0/nand2_0/a_7_10# datapath_0/ry1 GND GND nfet w=6 l=2
+  ad=42 pd=26 as=0 ps=0
M1901 datapath_0/fblock_0/fblock_one_0[6]/mux2_0/nand2_2/A datapath_0/ry1 Vdd Vdd pfet w=12 l=2
+  ad=84 pd=38 as=0 ps=0
M1902 datapath_0/fblock_0/fblock_one_0[6]/mux2_0/nand2_2/A datapath_0/g2 datapath_0/fblock_0/fblock_one_0[6]/mux2_0/nand2_0/a_7_10# GND nfet w=6 l=2
+  ad=36 pd=24 as=0 ps=0
M1903 Vdd datapath_0/g2 datapath_0/fblock_0/fblock_one_0[6]/mux2_0/nand2_2/A Vdd pfet w=12 l=2
+  ad=0 pd=0 as=0 ps=0
M1904 datapath_0/fblock_0/fblock_one_0[6]/mux2_0/nand2_2/a_7_10# datapath_0/fblock_0/fblock_one_0[6]/mux2_0/nand2_2/A GND GND nfet w=6 l=2
+  ad=42 pd=26 as=0 ps=0
M1905 datapath_0/fblock_0/fblock_one_0[6]/mux2_2/A datapath_0/fblock_0/fblock_one_0[6]/mux2_0/nand2_2/A Vdd Vdd pfet w=12 l=2
+  ad=84 pd=38 as=0 ps=0
M1906 datapath_0/fblock_0/fblock_one_0[6]/mux2_2/A datapath_0/fblock_0/fblock_one_0[6]/mux2_0/nand2_2/B datapath_0/fblock_0/fblock_one_0[6]/mux2_0/nand2_2/a_7_10# GND nfet w=6 l=2
+  ad=36 pd=24 as=0 ps=0
M1907 Vdd datapath_0/fblock_0/fblock_one_0[6]/mux2_0/nand2_2/B datapath_0/fblock_0/fblock_one_0[6]/mux2_2/A Vdd pfet w=12 l=2
+  ad=0 pd=0 as=0 ps=0
M1908 datapath_0/fblock_0/fblock_one_0[6]/mux2_0/nand2_1/a_7_10# GND GND GND nfet w=6 l=2
+  ad=42 pd=26 as=0 ps=0
M1909 datapath_0/fblock_0/fblock_one_0[6]/mux2_0/nand2_2/B GND Vdd Vdd pfet w=12 l=2
+  ad=84 pd=38 as=0 ps=0
M1910 datapath_0/fblock_0/fblock_one_0[6]/mux2_0/nand2_2/B datapath_0/fblock_0/fblock_one_0[6]/mux2_0/nand2_1/B datapath_0/fblock_0/fblock_one_0[6]/mux2_0/nand2_1/a_7_10# GND nfet w=6 l=2
+  ad=36 pd=24 as=0 ps=0
M1911 Vdd datapath_0/fblock_0/fblock_one_0[6]/mux2_0/nand2_1/B datapath_0/fblock_0/fblock_one_0[6]/mux2_0/nand2_2/B Vdd pfet w=12 l=2
+  ad=0 pd=0 as=0 ps=0
M1912 datapath_0/fblock_0/fblock_one_0[6]/mux2_1/nand2_1/B datapath_0/ry1 GND GND nfet w=5 l=2
+  ad=30 pd=22 as=0 ps=0
M1913 datapath_0/fblock_0/fblock_one_0[6]/mux2_1/nand2_1/B datapath_0/ry1 Vdd Vdd pfet w=10 l=2
+  ad=60 pd=32 as=0 ps=0
M1914 datapath_0/fblock_0/fblock_one_0[6]/mux2_1/nand2_0/a_7_10# datapath_0/ry1 GND GND nfet w=6 l=2
+  ad=42 pd=26 as=0 ps=0
M1915 datapath_0/fblock_0/fblock_one_0[6]/mux2_1/nand2_2/A datapath_0/ry1 Vdd Vdd pfet w=12 l=2
+  ad=84 pd=38 as=0 ps=0
M1916 datapath_0/fblock_0/fblock_one_0[6]/mux2_1/nand2_2/A GND datapath_0/fblock_0/fblock_one_0[6]/mux2_1/nand2_0/a_7_10# GND nfet w=6 l=2
+  ad=36 pd=24 as=0 ps=0
M1917 Vdd GND datapath_0/fblock_0/fblock_one_0[6]/mux2_1/nand2_2/A Vdd pfet w=12 l=2
+  ad=0 pd=0 as=0 ps=0
M1918 datapath_0/fblock_0/fblock_one_0[6]/mux2_1/nand2_2/a_7_10# datapath_0/fblock_0/fblock_one_0[6]/mux2_1/nand2_2/A GND GND nfet w=6 l=2
+  ad=42 pd=26 as=0 ps=0
M1919 datapath_0/fblock_0/fblock_one_0[6]/mux2_2/B datapath_0/fblock_0/fblock_one_0[6]/mux2_1/nand2_2/A Vdd Vdd pfet w=12 l=2
+  ad=84 pd=38 as=0 ps=0
M1920 datapath_0/fblock_0/fblock_one_0[6]/mux2_2/B datapath_0/fblock_0/fblock_one_0[6]/mux2_1/nand2_2/B datapath_0/fblock_0/fblock_one_0[6]/mux2_1/nand2_2/a_7_10# GND nfet w=6 l=2
+  ad=36 pd=24 as=0 ps=0
M1921 Vdd datapath_0/fblock_0/fblock_one_0[6]/mux2_1/nand2_2/B datapath_0/fblock_0/fblock_one_0[6]/mux2_2/B Vdd pfet w=12 l=2
+  ad=0 pd=0 as=0 ps=0
M1922 datapath_0/fblock_0/fblock_one_0[6]/mux2_1/nand2_1/a_7_10# datapath_0/g2 GND GND nfet w=6 l=2
+  ad=42 pd=26 as=0 ps=0
M1923 datapath_0/fblock_0/fblock_one_0[6]/mux2_1/nand2_2/B datapath_0/g2 Vdd Vdd pfet w=12 l=2
+  ad=84 pd=38 as=0 ps=0
M1924 datapath_0/fblock_0/fblock_one_0[6]/mux2_1/nand2_2/B datapath_0/fblock_0/fblock_one_0[6]/mux2_1/nand2_1/B datapath_0/fblock_0/fblock_one_0[6]/mux2_1/nand2_1/a_7_10# GND nfet w=6 l=2
+  ad=36 pd=24 as=0 ps=0
M1925 Vdd datapath_0/fblock_0/fblock_one_0[6]/mux2_1/nand2_1/B datapath_0/fblock_0/fblock_one_0[6]/mux2_1/nand2_2/B Vdd pfet w=12 l=2
+  ad=0 pd=0 as=0 ps=0
M1926 datapath_0/fblock_0/fblock_one_0[6]/mux2_2/nand2_1/B datapath_0/rx1 GND GND nfet w=5 l=2
+  ad=30 pd=22 as=0 ps=0
M1927 datapath_0/fblock_0/fblock_one_0[6]/mux2_2/nand2_1/B datapath_0/rx1 Vdd Vdd pfet w=10 l=2
+  ad=60 pd=32 as=0 ps=0
M1928 datapath_0/fblock_0/fblock_one_0[6]/mux2_2/nand2_0/a_7_10# datapath_0/rx1 GND GND nfet w=6 l=2
+  ad=42 pd=26 as=0 ps=0
M1929 datapath_0/fblock_0/fblock_one_0[6]/mux2_2/nand2_2/A datapath_0/rx1 Vdd Vdd pfet w=12 l=2
+  ad=84 pd=38 as=0 ps=0
M1930 datapath_0/fblock_0/fblock_one_0[6]/mux2_2/nand2_2/A datapath_0/fblock_0/fblock_one_0[6]/mux2_2/B datapath_0/fblock_0/fblock_one_0[6]/mux2_2/nand2_0/a_7_10# GND nfet w=6 l=2
+  ad=36 pd=24 as=0 ps=0
M1931 Vdd datapath_0/fblock_0/fblock_one_0[6]/mux2_2/B datapath_0/fblock_0/fblock_one_0[6]/mux2_2/nand2_2/A Vdd pfet w=12 l=2
+  ad=0 pd=0 as=0 ps=0
M1932 datapath_0/fblock_0/fblock_one_0[6]/mux2_2/nand2_2/a_7_10# datapath_0/fblock_0/fblock_one_0[6]/mux2_2/nand2_2/A GND GND nfet w=6 l=2
+  ad=42 pd=26 as=0 ps=0
M1933 datapath_0/latch_1/in1 datapath_0/fblock_0/fblock_one_0[6]/mux2_2/nand2_2/A Vdd Vdd pfet w=12 l=2
+  ad=84 pd=38 as=0 ps=0
M1934 datapath_0/latch_1/in1 datapath_0/fblock_0/fblock_one_0[6]/mux2_2/nand2_2/B datapath_0/fblock_0/fblock_one_0[6]/mux2_2/nand2_2/a_7_10# GND nfet w=6 l=2
+  ad=36 pd=24 as=0 ps=0
M1935 Vdd datapath_0/fblock_0/fblock_one_0[6]/mux2_2/nand2_2/B datapath_0/latch_1/in1 Vdd pfet w=12 l=2
+  ad=0 pd=0 as=0 ps=0
M1936 datapath_0/fblock_0/fblock_one_0[6]/mux2_2/nand2_1/a_7_10# datapath_0/fblock_0/fblock_one_0[6]/mux2_2/A GND GND nfet w=6 l=2
+  ad=42 pd=26 as=0 ps=0
M1937 datapath_0/fblock_0/fblock_one_0[6]/mux2_2/nand2_2/B datapath_0/fblock_0/fblock_one_0[6]/mux2_2/A Vdd Vdd pfet w=12 l=2
+  ad=84 pd=38 as=0 ps=0
M1938 datapath_0/fblock_0/fblock_one_0[6]/mux2_2/nand2_2/B datapath_0/fblock_0/fblock_one_0[6]/mux2_2/nand2_1/B datapath_0/fblock_0/fblock_one_0[6]/mux2_2/nand2_1/a_7_10# GND nfet w=6 l=2
+  ad=36 pd=24 as=0 ps=0
M1939 Vdd datapath_0/fblock_0/fblock_one_0[6]/mux2_2/nand2_1/B datapath_0/fblock_0/fblock_one_0[6]/mux2_2/nand2_2/B Vdd pfet w=12 l=2
+  ad=0 pd=0 as=0 ps=0
M1940 datapath_0/fblock_0/fblock_one_0[7]/mux2_0/nand2_1/B datapath_0/ry0 GND GND nfet w=5 l=2
+  ad=30 pd=22 as=0 ps=0
M1941 datapath_0/fblock_0/fblock_one_0[7]/mux2_0/nand2_1/B datapath_0/ry0 Vdd Vdd pfet w=10 l=2
+  ad=60 pd=32 as=0 ps=0
M1942 datapath_0/fblock_0/fblock_one_0[7]/mux2_0/nand2_0/a_7_10# datapath_0/ry0 GND GND nfet w=6 l=2
+  ad=42 pd=26 as=0 ps=0
M1943 datapath_0/fblock_0/fblock_one_0[7]/mux2_0/nand2_2/A datapath_0/ry0 Vdd Vdd pfet w=12 l=2
+  ad=84 pd=38 as=0 ps=0
M1944 datapath_0/fblock_0/fblock_one_0[7]/mux2_0/nand2_2/A datapath_0/g2 datapath_0/fblock_0/fblock_one_0[7]/mux2_0/nand2_0/a_7_10# GND nfet w=6 l=2
+  ad=36 pd=24 as=0 ps=0
M1945 Vdd datapath_0/g2 datapath_0/fblock_0/fblock_one_0[7]/mux2_0/nand2_2/A Vdd pfet w=12 l=2
+  ad=0 pd=0 as=0 ps=0
M1946 datapath_0/fblock_0/fblock_one_0[7]/mux2_0/nand2_2/a_7_10# datapath_0/fblock_0/fblock_one_0[7]/mux2_0/nand2_2/A GND GND nfet w=6 l=2
+  ad=42 pd=26 as=0 ps=0
M1947 datapath_0/fblock_0/fblock_one_0[7]/mux2_2/A datapath_0/fblock_0/fblock_one_0[7]/mux2_0/nand2_2/A Vdd Vdd pfet w=12 l=2
+  ad=84 pd=38 as=0 ps=0
M1948 datapath_0/fblock_0/fblock_one_0[7]/mux2_2/A datapath_0/fblock_0/fblock_one_0[7]/mux2_0/nand2_2/B datapath_0/fblock_0/fblock_one_0[7]/mux2_0/nand2_2/a_7_10# GND nfet w=6 l=2
+  ad=36 pd=24 as=0 ps=0
M1949 Vdd datapath_0/fblock_0/fblock_one_0[7]/mux2_0/nand2_2/B datapath_0/fblock_0/fblock_one_0[7]/mux2_2/A Vdd pfet w=12 l=2
+  ad=0 pd=0 as=0 ps=0
M1950 datapath_0/fblock_0/fblock_one_0[7]/mux2_0/nand2_1/a_7_10# GND GND GND nfet w=6 l=2
+  ad=42 pd=26 as=0 ps=0
M1951 datapath_0/fblock_0/fblock_one_0[7]/mux2_0/nand2_2/B GND Vdd Vdd pfet w=12 l=2
+  ad=84 pd=38 as=0 ps=0
M1952 datapath_0/fblock_0/fblock_one_0[7]/mux2_0/nand2_2/B datapath_0/fblock_0/fblock_one_0[7]/mux2_0/nand2_1/B datapath_0/fblock_0/fblock_one_0[7]/mux2_0/nand2_1/a_7_10# GND nfet w=6 l=2
+  ad=36 pd=24 as=0 ps=0
M1953 Vdd datapath_0/fblock_0/fblock_one_0[7]/mux2_0/nand2_1/B datapath_0/fblock_0/fblock_one_0[7]/mux2_0/nand2_2/B Vdd pfet w=12 l=2
+  ad=0 pd=0 as=0 ps=0
M1954 datapath_0/fblock_0/fblock_one_0[7]/mux2_1/nand2_1/B datapath_0/ry0 GND GND nfet w=5 l=2
+  ad=30 pd=22 as=0 ps=0
M1955 datapath_0/fblock_0/fblock_one_0[7]/mux2_1/nand2_1/B datapath_0/ry0 Vdd Vdd pfet w=10 l=2
+  ad=60 pd=32 as=0 ps=0
M1956 datapath_0/fblock_0/fblock_one_0[7]/mux2_1/nand2_0/a_7_10# datapath_0/ry0 GND GND nfet w=6 l=2
+  ad=42 pd=26 as=0 ps=0
M1957 datapath_0/fblock_0/fblock_one_0[7]/mux2_1/nand2_2/A datapath_0/ry0 Vdd Vdd pfet w=12 l=2
+  ad=84 pd=38 as=0 ps=0
M1958 datapath_0/fblock_0/fblock_one_0[7]/mux2_1/nand2_2/A GND datapath_0/fblock_0/fblock_one_0[7]/mux2_1/nand2_0/a_7_10# GND nfet w=6 l=2
+  ad=36 pd=24 as=0 ps=0
M1959 Vdd GND datapath_0/fblock_0/fblock_one_0[7]/mux2_1/nand2_2/A Vdd pfet w=12 l=2
+  ad=0 pd=0 as=0 ps=0
M1960 datapath_0/fblock_0/fblock_one_0[7]/mux2_1/nand2_2/a_7_10# datapath_0/fblock_0/fblock_one_0[7]/mux2_1/nand2_2/A GND GND nfet w=6 l=2
+  ad=42 pd=26 as=0 ps=0
M1961 datapath_0/fblock_0/fblock_one_0[7]/mux2_2/B datapath_0/fblock_0/fblock_one_0[7]/mux2_1/nand2_2/A Vdd Vdd pfet w=12 l=2
+  ad=84 pd=38 as=0 ps=0
M1962 datapath_0/fblock_0/fblock_one_0[7]/mux2_2/B datapath_0/fblock_0/fblock_one_0[7]/mux2_1/nand2_2/B datapath_0/fblock_0/fblock_one_0[7]/mux2_1/nand2_2/a_7_10# GND nfet w=6 l=2
+  ad=36 pd=24 as=0 ps=0
M1963 Vdd datapath_0/fblock_0/fblock_one_0[7]/mux2_1/nand2_2/B datapath_0/fblock_0/fblock_one_0[7]/mux2_2/B Vdd pfet w=12 l=2
+  ad=0 pd=0 as=0 ps=0
M1964 datapath_0/fblock_0/fblock_one_0[7]/mux2_1/nand2_1/a_7_10# datapath_0/g2 GND GND nfet w=6 l=2
+  ad=42 pd=26 as=0 ps=0
M1965 datapath_0/fblock_0/fblock_one_0[7]/mux2_1/nand2_2/B datapath_0/g2 Vdd Vdd pfet w=12 l=2
+  ad=84 pd=38 as=0 ps=0
M1966 datapath_0/fblock_0/fblock_one_0[7]/mux2_1/nand2_2/B datapath_0/fblock_0/fblock_one_0[7]/mux2_1/nand2_1/B datapath_0/fblock_0/fblock_one_0[7]/mux2_1/nand2_1/a_7_10# GND nfet w=6 l=2
+  ad=36 pd=24 as=0 ps=0
M1967 Vdd datapath_0/fblock_0/fblock_one_0[7]/mux2_1/nand2_1/B datapath_0/fblock_0/fblock_one_0[7]/mux2_1/nand2_2/B Vdd pfet w=12 l=2
+  ad=0 pd=0 as=0 ps=0
M1968 datapath_0/fblock_0/fblock_one_0[7]/mux2_2/nand2_1/B datapath_0/rx0 GND GND nfet w=5 l=2
+  ad=30 pd=22 as=0 ps=0
M1969 datapath_0/fblock_0/fblock_one_0[7]/mux2_2/nand2_1/B datapath_0/rx0 Vdd Vdd pfet w=10 l=2
+  ad=60 pd=32 as=0 ps=0
M1970 datapath_0/fblock_0/fblock_one_0[7]/mux2_2/nand2_0/a_7_10# datapath_0/rx0 GND GND nfet w=6 l=2
+  ad=42 pd=26 as=0 ps=0
M1971 datapath_0/fblock_0/fblock_one_0[7]/mux2_2/nand2_2/A datapath_0/rx0 Vdd Vdd pfet w=12 l=2
+  ad=84 pd=38 as=0 ps=0
M1972 datapath_0/fblock_0/fblock_one_0[7]/mux2_2/nand2_2/A datapath_0/fblock_0/fblock_one_0[7]/mux2_2/B datapath_0/fblock_0/fblock_one_0[7]/mux2_2/nand2_0/a_7_10# GND nfet w=6 l=2
+  ad=36 pd=24 as=0 ps=0
M1973 Vdd datapath_0/fblock_0/fblock_one_0[7]/mux2_2/B datapath_0/fblock_0/fblock_one_0[7]/mux2_2/nand2_2/A Vdd pfet w=12 l=2
+  ad=0 pd=0 as=0 ps=0
M1974 datapath_0/fblock_0/fblock_one_0[7]/mux2_2/nand2_2/a_7_10# datapath_0/fblock_0/fblock_one_0[7]/mux2_2/nand2_2/A GND GND nfet w=6 l=2
+  ad=42 pd=26 as=0 ps=0
M1975 datapath_0/latch_1/in0 datapath_0/fblock_0/fblock_one_0[7]/mux2_2/nand2_2/A Vdd Vdd pfet w=12 l=2
+  ad=84 pd=38 as=0 ps=0
M1976 datapath_0/latch_1/in0 datapath_0/fblock_0/fblock_one_0[7]/mux2_2/nand2_2/B datapath_0/fblock_0/fblock_one_0[7]/mux2_2/nand2_2/a_7_10# GND nfet w=6 l=2
+  ad=36 pd=24 as=0 ps=0
M1977 Vdd datapath_0/fblock_0/fblock_one_0[7]/mux2_2/nand2_2/B datapath_0/latch_1/in0 Vdd pfet w=12 l=2
+  ad=0 pd=0 as=0 ps=0
M1978 datapath_0/fblock_0/fblock_one_0[7]/mux2_2/nand2_1/a_7_10# datapath_0/fblock_0/fblock_one_0[7]/mux2_2/A GND GND nfet w=6 l=2
+  ad=42 pd=26 as=0 ps=0
M1979 datapath_0/fblock_0/fblock_one_0[7]/mux2_2/nand2_2/B datapath_0/fblock_0/fblock_one_0[7]/mux2_2/A Vdd Vdd pfet w=12 l=2
+  ad=84 pd=38 as=0 ps=0
M1980 datapath_0/fblock_0/fblock_one_0[7]/mux2_2/nand2_2/B datapath_0/fblock_0/fblock_one_0[7]/mux2_2/nand2_1/B datapath_0/fblock_0/fblock_one_0[7]/mux2_2/nand2_1/a_7_10# GND nfet w=6 l=2
+  ad=36 pd=24 as=0 ps=0
M1981 Vdd datapath_0/fblock_0/fblock_one_0[7]/mux2_2/nand2_1/B datapath_0/fblock_0/fblock_one_0[7]/mux2_2/nand2_2/B Vdd pfet w=12 l=2
+  ad=0 pd=0 as=0 ps=0
M1982 GND fsm_0/rd datapath_0/latch_4/latch_one_0[0]/new_latch_0/a_82_52# GND nfet w=5 l=2
+  ad=0 pd=0 as=30 ps=22
M1983 datapath_0/latch_4/latch_one_0[0]/new_latch_0/a_99_34# datapath_0/latch_4/latch_one_0[0]/new_latch_0/a_79_32# Vdd Vdd pfet w=10 l=2
+  ad=40 pd=28 as=0 ps=0
M1984 datapath_0/latch_4/latch_one_0[0]/new_latch_0/a_79_32# datapath_0/rx0 Vdd Vdd pfet w=10 l=2
+  ad=60 pd=32 as=0 ps=0
M1985 out0 datapath_0/latch_4/latch_one_0[0]/new_latch_0/a_82_52# datapath_0/latch_4/latch_one_0[0]/new_latch_0/a_99_34# Vdd pfet w=10 l=2
+  ad=60 pd=32 as=0 ps=0
M1986 datapath_0/latch_4/latch_one_0[0]/new_latch_0/a_82_34# datapath_0/latch_4/latch_one_0[0]/new_latch_0/a_79_32# GND GND nfet w=5 l=2
+  ad=20 pd=18 as=0 ps=0
M1987 datapath_0/latch_4/latch_one_0[0]/new_latch_0/a_79_32# datapath_0/rx0 GND GND nfet w=5 l=2
+  ad=30 pd=22 as=0 ps=0
M1988 out0 fsm_0/rd datapath_0/latch_4/latch_one_0[0]/new_latch_0/a_82_34# GND nfet w=5 l=2
+  ad=30 pd=22 as=0 ps=0
M1989 Vdd fsm_0/rd datapath_0/latch_4/latch_one_0[0]/new_latch_0/a_82_52# Vdd pfet w=10 l=2
+  ad=0 pd=0 as=60 ps=32
M1990 GND fsm_0/rd datapath_0/latch_4/latch_one_0[1]/new_latch_0/a_82_52# GND nfet w=5 l=2
+  ad=0 pd=0 as=30 ps=22
M1991 datapath_0/latch_4/latch_one_0[1]/new_latch_0/a_99_34# datapath_0/latch_4/latch_one_0[1]/new_latch_0/a_79_32# Vdd Vdd pfet w=10 l=2
+  ad=40 pd=28 as=0 ps=0
M1992 datapath_0/latch_4/latch_one_0[1]/new_latch_0/a_79_32# datapath_0/rx1 Vdd Vdd pfet w=10 l=2
+  ad=60 pd=32 as=0 ps=0
M1993 out1 datapath_0/latch_4/latch_one_0[1]/new_latch_0/a_82_52# datapath_0/latch_4/latch_one_0[1]/new_latch_0/a_99_34# Vdd pfet w=10 l=2
+  ad=60 pd=32 as=0 ps=0
M1994 datapath_0/latch_4/latch_one_0[1]/new_latch_0/a_82_34# datapath_0/latch_4/latch_one_0[1]/new_latch_0/a_79_32# GND GND nfet w=5 l=2
+  ad=20 pd=18 as=0 ps=0
M1995 datapath_0/latch_4/latch_one_0[1]/new_latch_0/a_79_32# datapath_0/rx1 GND GND nfet w=5 l=2
+  ad=30 pd=22 as=0 ps=0
M1996 out1 fsm_0/rd datapath_0/latch_4/latch_one_0[1]/new_latch_0/a_82_34# GND nfet w=5 l=2
+  ad=30 pd=22 as=0 ps=0
M1997 Vdd fsm_0/rd datapath_0/latch_4/latch_one_0[1]/new_latch_0/a_82_52# Vdd pfet w=10 l=2
+  ad=0 pd=0 as=60 ps=32
M1998 GND fsm_0/rd datapath_0/latch_4/latch_one_0[2]/new_latch_0/a_82_52# GND nfet w=5 l=2
+  ad=0 pd=0 as=30 ps=22
M1999 datapath_0/latch_4/latch_one_0[2]/new_latch_0/a_99_34# datapath_0/latch_4/latch_one_0[2]/new_latch_0/a_79_32# Vdd Vdd pfet w=10 l=2
+  ad=40 pd=28 as=0 ps=0
M2000 datapath_0/latch_4/latch_one_0[2]/new_latch_0/a_79_32# datapath_0/rx2 Vdd Vdd pfet w=10 l=2
+  ad=60 pd=32 as=0 ps=0
M2001 out2 datapath_0/latch_4/latch_one_0[2]/new_latch_0/a_82_52# datapath_0/latch_4/latch_one_0[2]/new_latch_0/a_99_34# Vdd pfet w=10 l=2
+  ad=60 pd=32 as=0 ps=0
M2002 datapath_0/latch_4/latch_one_0[2]/new_latch_0/a_82_34# datapath_0/latch_4/latch_one_0[2]/new_latch_0/a_79_32# GND GND nfet w=5 l=2
+  ad=20 pd=18 as=0 ps=0
M2003 datapath_0/latch_4/latch_one_0[2]/new_latch_0/a_79_32# datapath_0/rx2 GND GND nfet w=5 l=2
+  ad=30 pd=22 as=0 ps=0
M2004 out2 fsm_0/rd datapath_0/latch_4/latch_one_0[2]/new_latch_0/a_82_34# GND nfet w=5 l=2
+  ad=30 pd=22 as=0 ps=0
M2005 Vdd fsm_0/rd datapath_0/latch_4/latch_one_0[2]/new_latch_0/a_82_52# Vdd pfet w=10 l=2
+  ad=0 pd=0 as=60 ps=32
M2006 GND fsm_0/rd datapath_0/latch_4/latch_one_0[3]/new_latch_0/a_82_52# GND nfet w=5 l=2
+  ad=0 pd=0 as=30 ps=22
M2007 datapath_0/latch_4/latch_one_0[3]/new_latch_0/a_99_34# datapath_0/latch_4/latch_one_0[3]/new_latch_0/a_79_32# Vdd Vdd pfet w=10 l=2
+  ad=40 pd=28 as=0 ps=0
M2008 datapath_0/latch_4/latch_one_0[3]/new_latch_0/a_79_32# datapath_0/rx3 Vdd Vdd pfet w=10 l=2
+  ad=60 pd=32 as=0 ps=0
M2009 out3 datapath_0/latch_4/latch_one_0[3]/new_latch_0/a_82_52# datapath_0/latch_4/latch_one_0[3]/new_latch_0/a_99_34# Vdd pfet w=10 l=2
+  ad=60 pd=32 as=0 ps=0
M2010 datapath_0/latch_4/latch_one_0[3]/new_latch_0/a_82_34# datapath_0/latch_4/latch_one_0[3]/new_latch_0/a_79_32# GND GND nfet w=5 l=2
+  ad=20 pd=18 as=0 ps=0
M2011 datapath_0/latch_4/latch_one_0[3]/new_latch_0/a_79_32# datapath_0/rx3 GND GND nfet w=5 l=2
+  ad=30 pd=22 as=0 ps=0
M2012 out3 fsm_0/rd datapath_0/latch_4/latch_one_0[3]/new_latch_0/a_82_34# GND nfet w=5 l=2
+  ad=30 pd=22 as=0 ps=0
M2013 Vdd fsm_0/rd datapath_0/latch_4/latch_one_0[3]/new_latch_0/a_82_52# Vdd pfet w=10 l=2
+  ad=0 pd=0 as=60 ps=32
M2014 GND fsm_0/rd datapath_0/latch_4/latch_one_0[4]/new_latch_0/a_82_52# GND nfet w=5 l=2
+  ad=0 pd=0 as=30 ps=22
M2015 datapath_0/latch_4/latch_one_0[4]/new_latch_0/a_99_34# datapath_0/latch_4/latch_one_0[4]/new_latch_0/a_79_32# Vdd Vdd pfet w=10 l=2
+  ad=40 pd=28 as=0 ps=0
M2016 datapath_0/latch_4/latch_one_0[4]/new_latch_0/a_79_32# datapath_0/rx4 Vdd Vdd pfet w=10 l=2
+  ad=60 pd=32 as=0 ps=0
M2017 out4 datapath_0/latch_4/latch_one_0[4]/new_latch_0/a_82_52# datapath_0/latch_4/latch_one_0[4]/new_latch_0/a_99_34# Vdd pfet w=10 l=2
+  ad=60 pd=32 as=0 ps=0
M2018 datapath_0/latch_4/latch_one_0[4]/new_latch_0/a_82_34# datapath_0/latch_4/latch_one_0[4]/new_latch_0/a_79_32# GND GND nfet w=5 l=2
+  ad=20 pd=18 as=0 ps=0
M2019 datapath_0/latch_4/latch_one_0[4]/new_latch_0/a_79_32# datapath_0/rx4 GND GND nfet w=5 l=2
+  ad=30 pd=22 as=0 ps=0
M2020 out4 fsm_0/rd datapath_0/latch_4/latch_one_0[4]/new_latch_0/a_82_34# GND nfet w=5 l=2
+  ad=30 pd=22 as=0 ps=0
M2021 Vdd fsm_0/rd datapath_0/latch_4/latch_one_0[4]/new_latch_0/a_82_52# Vdd pfet w=10 l=2
+  ad=0 pd=0 as=60 ps=32
M2022 GND fsm_0/rd datapath_0/latch_4/latch_one_0[5]/new_latch_0/a_82_52# GND nfet w=5 l=2
+  ad=0 pd=0 as=30 ps=22
M2023 datapath_0/latch_4/latch_one_0[5]/new_latch_0/a_99_34# datapath_0/latch_4/latch_one_0[5]/new_latch_0/a_79_32# Vdd Vdd pfet w=10 l=2
+  ad=40 pd=28 as=0 ps=0
M2024 datapath_0/latch_4/latch_one_0[5]/new_latch_0/a_79_32# datapath_0/rx5 Vdd Vdd pfet w=10 l=2
+  ad=60 pd=32 as=0 ps=0
M2025 out5 datapath_0/latch_4/latch_one_0[5]/new_latch_0/a_82_52# datapath_0/latch_4/latch_one_0[5]/new_latch_0/a_99_34# Vdd pfet w=10 l=2
+  ad=60 pd=32 as=0 ps=0
M2026 datapath_0/latch_4/latch_one_0[5]/new_latch_0/a_82_34# datapath_0/latch_4/latch_one_0[5]/new_latch_0/a_79_32# GND GND nfet w=5 l=2
+  ad=20 pd=18 as=0 ps=0
M2027 datapath_0/latch_4/latch_one_0[5]/new_latch_0/a_79_32# datapath_0/rx5 GND GND nfet w=5 l=2
+  ad=30 pd=22 as=0 ps=0
M2028 out5 fsm_0/rd datapath_0/latch_4/latch_one_0[5]/new_latch_0/a_82_34# GND nfet w=5 l=2
+  ad=30 pd=22 as=0 ps=0
M2029 Vdd fsm_0/rd datapath_0/latch_4/latch_one_0[5]/new_latch_0/a_82_52# Vdd pfet w=10 l=2
+  ad=0 pd=0 as=60 ps=32
M2030 GND fsm_0/rd datapath_0/latch_4/latch_one_0[6]/new_latch_0/a_82_52# GND nfet w=5 l=2
+  ad=0 pd=0 as=30 ps=22
M2031 datapath_0/latch_4/latch_one_0[6]/new_latch_0/a_99_34# datapath_0/latch_4/latch_one_0[6]/new_latch_0/a_79_32# Vdd Vdd pfet w=10 l=2
+  ad=40 pd=28 as=0 ps=0
M2032 datapath_0/latch_4/latch_one_0[6]/new_latch_0/a_79_32# datapath_0/rx6 Vdd Vdd pfet w=10 l=2
+  ad=60 pd=32 as=0 ps=0
M2033 out6 datapath_0/latch_4/latch_one_0[6]/new_latch_0/a_82_52# datapath_0/latch_4/latch_one_0[6]/new_latch_0/a_99_34# Vdd pfet w=10 l=2
+  ad=60 pd=32 as=0 ps=0
M2034 datapath_0/latch_4/latch_one_0[6]/new_latch_0/a_82_34# datapath_0/latch_4/latch_one_0[6]/new_latch_0/a_79_32# GND GND nfet w=5 l=2
+  ad=20 pd=18 as=0 ps=0
M2035 datapath_0/latch_4/latch_one_0[6]/new_latch_0/a_79_32# datapath_0/rx6 GND GND nfet w=5 l=2
+  ad=30 pd=22 as=0 ps=0
M2036 out6 fsm_0/rd datapath_0/latch_4/latch_one_0[6]/new_latch_0/a_82_34# GND nfet w=5 l=2
+  ad=30 pd=22 as=0 ps=0
M2037 Vdd fsm_0/rd datapath_0/latch_4/latch_one_0[6]/new_latch_0/a_82_52# Vdd pfet w=10 l=2
+  ad=0 pd=0 as=60 ps=32
M2038 GND fsm_0/rd datapath_0/latch_4/latch_one_0[7]/new_latch_0/a_82_52# GND nfet w=5 l=2
+  ad=0 pd=0 as=30 ps=22
M2039 datapath_0/latch_4/latch_one_0[7]/new_latch_0/a_99_34# datapath_0/latch_4/latch_one_0[7]/new_latch_0/a_79_32# Vdd Vdd pfet w=10 l=2
+  ad=40 pd=28 as=0 ps=0
M2040 datapath_0/latch_4/latch_one_0[7]/new_latch_0/a_79_32# datapath_0/rx7 Vdd Vdd pfet w=10 l=2
+  ad=60 pd=32 as=0 ps=0
M2041 out7 datapath_0/latch_4/latch_one_0[7]/new_latch_0/a_82_52# datapath_0/latch_4/latch_one_0[7]/new_latch_0/a_99_34# Vdd pfet w=10 l=2
+  ad=60 pd=32 as=0 ps=0
M2042 datapath_0/latch_4/latch_one_0[7]/new_latch_0/a_82_34# datapath_0/latch_4/latch_one_0[7]/new_latch_0/a_79_32# GND GND nfet w=5 l=2
+  ad=20 pd=18 as=0 ps=0
M2043 datapath_0/latch_4/latch_one_0[7]/new_latch_0/a_79_32# datapath_0/rx7 GND GND nfet w=5 l=2
+  ad=30 pd=22 as=0 ps=0
M2044 out7 fsm_0/rd datapath_0/latch_4/latch_one_0[7]/new_latch_0/a_82_34# GND nfet w=5 l=2
+  ad=30 pd=22 as=0 ps=0
M2045 Vdd fsm_0/rd datapath_0/latch_4/latch_one_0[7]/new_latch_0/a_82_52# Vdd pfet w=10 l=2
+  ad=0 pd=0 as=60 ps=32
M2046 datapath_0/register_0/register_one_0[0]/tp1 datapath_0/register_0/register_one_0[0]/inv_0/in GND GND nfet w=5 l=2
+  ad=60 pd=44 as=0 ps=0
M2047 datapath_0/register_0/register_one_0[0]/tp1 datapath_0/register_0/register_one_0[0]/inv_0/in Vdd Vdd pfet w=10 l=2
+  ad=120 pd=64 as=0 ps=0
M2048 datapath_0/register_0/register_one_0[0]/inv_0/in datapath_0/register_0/register_one_0[0]/data GND GND nfet w=5 l=2
+  ad=30 pd=22 as=0 ps=0
M2049 datapath_0/register_0/register_one_0[0]/inv_0/in datapath_0/register_0/register_one_0[0]/data Vdd Vdd pfet w=10 l=2
+  ad=60 pd=32 as=0 ps=0
M2050 datapath_0/register_0/register_one_0[0]/notw fsm_0/reg0w GND GND nfet w=5 l=2
+  ad=30 pd=22 as=0 ps=0
M2051 datapath_0/register_0/register_one_0[0]/notw fsm_0/reg0w Vdd Vdd pfet w=10 l=2
+  ad=60 pd=32 as=0 ps=0
M2052 GND datapath_0/register_0/register_one_0[0]/notw datapath_0/register_0/register_one_0[0]/new_latch_0/a_82_52# GND nfet w=5 l=2
+  ad=0 pd=0 as=30 ps=22
M2053 datapath_0/register_0/register_one_0[0]/new_latch_0/a_99_34# datapath_0/register_0/register_one_0[0]/new_latch_0/a_79_32# Vdd Vdd pfet w=10 l=2
+  ad=40 pd=28 as=0 ps=0
M2054 datapath_0/register_0/register_one_0[0]/new_latch_0/a_79_32# datapath_0/register_0/register_one_0[0]/data Vdd Vdd pfet w=10 l=2
+  ad=60 pd=32 as=0 ps=0
M2055 datapath_0/register_0/register_one_0[0]/tp1 datapath_0/register_0/register_one_0[0]/new_latch_0/a_82_52# datapath_0/register_0/register_one_0[0]/new_latch_0/a_99_34# Vdd pfet w=10 l=2
+  ad=0 pd=0 as=0 ps=0
M2056 datapath_0/register_0/register_one_0[0]/new_latch_0/a_82_34# datapath_0/register_0/register_one_0[0]/new_latch_0/a_79_32# GND GND nfet w=5 l=2
+  ad=20 pd=18 as=0 ps=0
M2057 datapath_0/register_0/register_one_0[0]/new_latch_0/a_79_32# datapath_0/register_0/register_one_0[0]/data GND GND nfet w=5 l=2
+  ad=30 pd=22 as=0 ps=0
M2058 datapath_0/register_0/register_one_0[0]/tp1 datapath_0/register_0/register_one_0[0]/notw datapath_0/register_0/register_one_0[0]/new_latch_0/a_82_34# GND nfet w=5 l=2
+  ad=0 pd=0 as=0 ps=0
M2059 Vdd datapath_0/register_0/register_one_0[0]/notw datapath_0/register_0/register_one_0[0]/new_latch_0/a_82_52# Vdd pfet w=10 l=2
+  ad=0 pd=0 as=60 ps=32
M2060 GND fsm_0/reg0w datapath_0/register_0/register_one_0[0]/new_latch_1/a_82_52# GND nfet w=5 l=2
+  ad=0 pd=0 as=30 ps=22
M2061 datapath_0/register_0/register_one_0[0]/new_latch_1/a_99_34# datapath_0/register_0/register_one_0[0]/new_latch_1/a_79_32# Vdd Vdd pfet w=10 l=2
+  ad=40 pd=28 as=0 ps=0
M2062 datapath_0/register_0/register_one_0[0]/new_latch_1/a_79_32# datapath_0/wz0 Vdd Vdd pfet w=10 l=2
+  ad=60 pd=32 as=0 ps=0
M2063 datapath_0/register_0/register_one_0[0]/data datapath_0/register_0/register_one_0[0]/new_latch_1/a_82_52# datapath_0/register_0/register_one_0[0]/new_latch_1/a_99_34# Vdd pfet w=10 l=2
+  ad=60 pd=32 as=0 ps=0
M2064 datapath_0/register_0/register_one_0[0]/new_latch_1/a_82_34# datapath_0/register_0/register_one_0[0]/new_latch_1/a_79_32# GND GND nfet w=5 l=2
+  ad=20 pd=18 as=0 ps=0
M2065 datapath_0/register_0/register_one_0[0]/new_latch_1/a_79_32# datapath_0/wz0 GND GND nfet w=5 l=2
+  ad=30 pd=22 as=0 ps=0
M2066 datapath_0/register_0/register_one_0[0]/data fsm_0/reg0w datapath_0/register_0/register_one_0[0]/new_latch_1/a_82_34# GND nfet w=5 l=2
+  ad=30 pd=22 as=0 ps=0
M2067 Vdd fsm_0/reg0w datapath_0/register_0/register_one_0[0]/new_latch_1/a_82_52# Vdd pfet w=10 l=2
+  ad=0 pd=0 as=60 ps=32
M2068 GND fsm_0/reg0r0 datapath_0/register_0/register_one_0[0]/new_latch_2/a_82_52# GND nfet w=5 l=2
+  ad=0 pd=0 as=30 ps=22
M2069 datapath_0/register_0/register_one_0[0]/new_latch_2/a_99_34# datapath_0/register_0/register_one_0[0]/new_latch_2/a_79_32# Vdd Vdd pfet w=10 l=2
+  ad=40 pd=28 as=0 ps=0
M2070 datapath_0/register_0/register_one_0[0]/new_latch_2/a_79_32# datapath_0/register_0/register_one_0[0]/data Vdd Vdd pfet w=10 l=2
+  ad=60 pd=32 as=0 ps=0
M2071 datapath_0/rx0 datapath_0/register_0/register_one_0[0]/new_latch_2/a_82_52# datapath_0/register_0/register_one_0[0]/new_latch_2/a_99_34# Vdd pfet w=10 l=2
+  ad=120 pd=64 as=0 ps=0
M2072 datapath_0/register_0/register_one_0[0]/new_latch_2/a_82_34# datapath_0/register_0/register_one_0[0]/new_latch_2/a_79_32# GND GND nfet w=5 l=2
+  ad=20 pd=18 as=0 ps=0
M2073 datapath_0/register_0/register_one_0[0]/new_latch_2/a_79_32# datapath_0/register_0/register_one_0[0]/data GND GND nfet w=5 l=2
+  ad=30 pd=22 as=0 ps=0
M2074 datapath_0/rx0 fsm_0/reg0r0 datapath_0/register_0/register_one_0[0]/new_latch_2/a_82_34# GND nfet w=5 l=2
+  ad=60 pd=44 as=0 ps=0
M2075 Vdd fsm_0/reg0r0 datapath_0/register_0/register_one_0[0]/new_latch_2/a_82_52# Vdd pfet w=10 l=2
+  ad=0 pd=0 as=60 ps=32
M2076 GND datapath_0/reg1r2 datapath_0/register_0/register_one_0[0]/new_latch_3/a_82_52# GND nfet w=5 l=2
+  ad=0 pd=0 as=30 ps=22
M2077 datapath_0/register_0/register_one_0[0]/new_latch_3/a_99_34# datapath_0/register_0/register_one_0[0]/new_latch_3/a_79_32# Vdd Vdd pfet w=10 l=2
+  ad=40 pd=28 as=0 ps=0
M2078 datapath_0/register_0/register_one_0[0]/new_latch_3/a_79_32# datapath_0/register_0/register_one_0[0]/data Vdd Vdd pfet w=10 l=2
+  ad=60 pd=32 as=0 ps=0
M2079 datapath_0/ry0 datapath_0/register_0/register_one_0[0]/new_latch_3/a_82_52# datapath_0/register_0/register_one_0[0]/new_latch_3/a_99_34# Vdd pfet w=10 l=2
+  ad=120 pd=64 as=0 ps=0
M2080 datapath_0/register_0/register_one_0[0]/new_latch_3/a_82_34# datapath_0/register_0/register_one_0[0]/new_latch_3/a_79_32# GND GND nfet w=5 l=2
+  ad=20 pd=18 as=0 ps=0
M2081 datapath_0/register_0/register_one_0[0]/new_latch_3/a_79_32# datapath_0/register_0/register_one_0[0]/data GND GND nfet w=5 l=2
+  ad=30 pd=22 as=0 ps=0
M2082 datapath_0/ry0 datapath_0/reg1r2 datapath_0/register_0/register_one_0[0]/new_latch_3/a_82_34# GND nfet w=5 l=2
+  ad=60 pd=44 as=0 ps=0
M2083 Vdd datapath_0/reg1r2 datapath_0/register_0/register_one_0[0]/new_latch_3/a_82_52# Vdd pfet w=10 l=2
+  ad=0 pd=0 as=60 ps=32
M2084 datapath_0/register_0/register_one_0[1]/tp1 datapath_0/register_0/register_one_0[1]/inv_0/in GND GND nfet w=5 l=2
+  ad=60 pd=44 as=0 ps=0
M2085 datapath_0/register_0/register_one_0[1]/tp1 datapath_0/register_0/register_one_0[1]/inv_0/in Vdd Vdd pfet w=10 l=2
+  ad=120 pd=64 as=0 ps=0
M2086 datapath_0/register_0/register_one_0[1]/inv_0/in datapath_0/register_0/register_one_0[1]/data GND GND nfet w=5 l=2
+  ad=30 pd=22 as=0 ps=0
M2087 datapath_0/register_0/register_one_0[1]/inv_0/in datapath_0/register_0/register_one_0[1]/data Vdd Vdd pfet w=10 l=2
+  ad=60 pd=32 as=0 ps=0
M2088 datapath_0/register_0/register_one_0[1]/notw fsm_0/reg0w GND GND nfet w=5 l=2
+  ad=30 pd=22 as=0 ps=0
M2089 datapath_0/register_0/register_one_0[1]/notw fsm_0/reg0w Vdd Vdd pfet w=10 l=2
+  ad=60 pd=32 as=0 ps=0
M2090 GND datapath_0/register_0/register_one_0[1]/notw datapath_0/register_0/register_one_0[1]/new_latch_0/a_82_52# GND nfet w=5 l=2
+  ad=0 pd=0 as=30 ps=22
M2091 datapath_0/register_0/register_one_0[1]/new_latch_0/a_99_34# datapath_0/register_0/register_one_0[1]/new_latch_0/a_79_32# Vdd Vdd pfet w=10 l=2
+  ad=40 pd=28 as=0 ps=0
M2092 datapath_0/register_0/register_one_0[1]/new_latch_0/a_79_32# datapath_0/register_0/register_one_0[1]/data Vdd Vdd pfet w=10 l=2
+  ad=60 pd=32 as=0 ps=0
M2093 datapath_0/register_0/register_one_0[1]/tp1 datapath_0/register_0/register_one_0[1]/new_latch_0/a_82_52# datapath_0/register_0/register_one_0[1]/new_latch_0/a_99_34# Vdd pfet w=10 l=2
+  ad=0 pd=0 as=0 ps=0
M2094 datapath_0/register_0/register_one_0[1]/new_latch_0/a_82_34# datapath_0/register_0/register_one_0[1]/new_latch_0/a_79_32# GND GND nfet w=5 l=2
+  ad=20 pd=18 as=0 ps=0
M2095 datapath_0/register_0/register_one_0[1]/new_latch_0/a_79_32# datapath_0/register_0/register_one_0[1]/data GND GND nfet w=5 l=2
+  ad=30 pd=22 as=0 ps=0
M2096 datapath_0/register_0/register_one_0[1]/tp1 datapath_0/register_0/register_one_0[1]/notw datapath_0/register_0/register_one_0[1]/new_latch_0/a_82_34# GND nfet w=5 l=2
+  ad=0 pd=0 as=0 ps=0
M2097 Vdd datapath_0/register_0/register_one_0[1]/notw datapath_0/register_0/register_one_0[1]/new_latch_0/a_82_52# Vdd pfet w=10 l=2
+  ad=0 pd=0 as=60 ps=32
M2098 GND fsm_0/reg0w datapath_0/register_0/register_one_0[1]/new_latch_1/a_82_52# GND nfet w=5 l=2
+  ad=0 pd=0 as=30 ps=22
M2099 datapath_0/register_0/register_one_0[1]/new_latch_1/a_99_34# datapath_0/register_0/register_one_0[1]/new_latch_1/a_79_32# Vdd Vdd pfet w=10 l=2
+  ad=40 pd=28 as=0 ps=0
M2100 datapath_0/register_0/register_one_0[1]/new_latch_1/a_79_32# datapath_0/wz1 Vdd Vdd pfet w=10 l=2
+  ad=60 pd=32 as=0 ps=0
M2101 datapath_0/register_0/register_one_0[1]/data datapath_0/register_0/register_one_0[1]/new_latch_1/a_82_52# datapath_0/register_0/register_one_0[1]/new_latch_1/a_99_34# Vdd pfet w=10 l=2
+  ad=60 pd=32 as=0 ps=0
M2102 datapath_0/register_0/register_one_0[1]/new_latch_1/a_82_34# datapath_0/register_0/register_one_0[1]/new_latch_1/a_79_32# GND GND nfet w=5 l=2
+  ad=20 pd=18 as=0 ps=0
M2103 datapath_0/register_0/register_one_0[1]/new_latch_1/a_79_32# datapath_0/wz1 GND GND nfet w=5 l=2
+  ad=30 pd=22 as=0 ps=0
M2104 datapath_0/register_0/register_one_0[1]/data fsm_0/reg0w datapath_0/register_0/register_one_0[1]/new_latch_1/a_82_34# GND nfet w=5 l=2
+  ad=30 pd=22 as=0 ps=0
M2105 Vdd fsm_0/reg0w datapath_0/register_0/register_one_0[1]/new_latch_1/a_82_52# Vdd pfet w=10 l=2
+  ad=0 pd=0 as=60 ps=32
M2106 GND fsm_0/reg0r0 datapath_0/register_0/register_one_0[1]/new_latch_2/a_82_52# GND nfet w=5 l=2
+  ad=0 pd=0 as=30 ps=22
M2107 datapath_0/register_0/register_one_0[1]/new_latch_2/a_99_34# datapath_0/register_0/register_one_0[1]/new_latch_2/a_79_32# Vdd Vdd pfet w=10 l=2
+  ad=40 pd=28 as=0 ps=0
M2108 datapath_0/register_0/register_one_0[1]/new_latch_2/a_79_32# datapath_0/register_0/register_one_0[1]/data Vdd Vdd pfet w=10 l=2
+  ad=60 pd=32 as=0 ps=0
M2109 datapath_0/rx1 datapath_0/register_0/register_one_0[1]/new_latch_2/a_82_52# datapath_0/register_0/register_one_0[1]/new_latch_2/a_99_34# Vdd pfet w=10 l=2
+  ad=120 pd=64 as=0 ps=0
M2110 datapath_0/register_0/register_one_0[1]/new_latch_2/a_82_34# datapath_0/register_0/register_one_0[1]/new_latch_2/a_79_32# GND GND nfet w=5 l=2
+  ad=20 pd=18 as=0 ps=0
M2111 datapath_0/register_0/register_one_0[1]/new_latch_2/a_79_32# datapath_0/register_0/register_one_0[1]/data GND GND nfet w=5 l=2
+  ad=30 pd=22 as=0 ps=0
M2112 datapath_0/rx1 fsm_0/reg0r0 datapath_0/register_0/register_one_0[1]/new_latch_2/a_82_34# GND nfet w=5 l=2
+  ad=60 pd=44 as=0 ps=0
M2113 Vdd fsm_0/reg0r0 datapath_0/register_0/register_one_0[1]/new_latch_2/a_82_52# Vdd pfet w=10 l=2
+  ad=0 pd=0 as=60 ps=32
M2114 GND datapath_0/reg1r2 datapath_0/register_0/register_one_0[1]/new_latch_3/a_82_52# GND nfet w=5 l=2
+  ad=0 pd=0 as=30 ps=22
M2115 datapath_0/register_0/register_one_0[1]/new_latch_3/a_99_34# datapath_0/register_0/register_one_0[1]/new_latch_3/a_79_32# Vdd Vdd pfet w=10 l=2
+  ad=40 pd=28 as=0 ps=0
M2116 datapath_0/register_0/register_one_0[1]/new_latch_3/a_79_32# datapath_0/register_0/register_one_0[1]/data Vdd Vdd pfet w=10 l=2
+  ad=60 pd=32 as=0 ps=0
M2117 datapath_0/ry1 datapath_0/register_0/register_one_0[1]/new_latch_3/a_82_52# datapath_0/register_0/register_one_0[1]/new_latch_3/a_99_34# Vdd pfet w=10 l=2
+  ad=120 pd=64 as=0 ps=0
M2118 datapath_0/register_0/register_one_0[1]/new_latch_3/a_82_34# datapath_0/register_0/register_one_0[1]/new_latch_3/a_79_32# GND GND nfet w=5 l=2
+  ad=20 pd=18 as=0 ps=0
M2119 datapath_0/register_0/register_one_0[1]/new_latch_3/a_79_32# datapath_0/register_0/register_one_0[1]/data GND GND nfet w=5 l=2
+  ad=30 pd=22 as=0 ps=0
M2120 datapath_0/ry1 datapath_0/reg1r2 datapath_0/register_0/register_one_0[1]/new_latch_3/a_82_34# GND nfet w=5 l=2
+  ad=60 pd=44 as=0 ps=0
M2121 Vdd datapath_0/reg1r2 datapath_0/register_0/register_one_0[1]/new_latch_3/a_82_52# Vdd pfet w=10 l=2
+  ad=0 pd=0 as=60 ps=32
M2122 datapath_0/register_0/register_one_0[2]/tp1 datapath_0/register_0/register_one_0[2]/inv_0/in GND GND nfet w=5 l=2
+  ad=60 pd=44 as=0 ps=0
M2123 datapath_0/register_0/register_one_0[2]/tp1 datapath_0/register_0/register_one_0[2]/inv_0/in Vdd Vdd pfet w=10 l=2
+  ad=120 pd=64 as=0 ps=0
M2124 datapath_0/register_0/register_one_0[2]/inv_0/in datapath_0/register_0/register_one_0[2]/data GND GND nfet w=5 l=2
+  ad=30 pd=22 as=0 ps=0
M2125 datapath_0/register_0/register_one_0[2]/inv_0/in datapath_0/register_0/register_one_0[2]/data Vdd Vdd pfet w=10 l=2
+  ad=60 pd=32 as=0 ps=0
M2126 datapath_0/register_0/register_one_0[2]/notw fsm_0/reg0w GND GND nfet w=5 l=2
+  ad=30 pd=22 as=0 ps=0
M2127 datapath_0/register_0/register_one_0[2]/notw fsm_0/reg0w Vdd Vdd pfet w=10 l=2
+  ad=60 pd=32 as=0 ps=0
M2128 GND datapath_0/register_0/register_one_0[2]/notw datapath_0/register_0/register_one_0[2]/new_latch_0/a_82_52# GND nfet w=5 l=2
+  ad=0 pd=0 as=30 ps=22
M2129 datapath_0/register_0/register_one_0[2]/new_latch_0/a_99_34# datapath_0/register_0/register_one_0[2]/new_latch_0/a_79_32# Vdd Vdd pfet w=10 l=2
+  ad=40 pd=28 as=0 ps=0
M2130 datapath_0/register_0/register_one_0[2]/new_latch_0/a_79_32# datapath_0/register_0/register_one_0[2]/data Vdd Vdd pfet w=10 l=2
+  ad=60 pd=32 as=0 ps=0
M2131 datapath_0/register_0/register_one_0[2]/tp1 datapath_0/register_0/register_one_0[2]/new_latch_0/a_82_52# datapath_0/register_0/register_one_0[2]/new_latch_0/a_99_34# Vdd pfet w=10 l=2
+  ad=0 pd=0 as=0 ps=0
M2132 datapath_0/register_0/register_one_0[2]/new_latch_0/a_82_34# datapath_0/register_0/register_one_0[2]/new_latch_0/a_79_32# GND GND nfet w=5 l=2
+  ad=20 pd=18 as=0 ps=0
M2133 datapath_0/register_0/register_one_0[2]/new_latch_0/a_79_32# datapath_0/register_0/register_one_0[2]/data GND GND nfet w=5 l=2
+  ad=30 pd=22 as=0 ps=0
M2134 datapath_0/register_0/register_one_0[2]/tp1 datapath_0/register_0/register_one_0[2]/notw datapath_0/register_0/register_one_0[2]/new_latch_0/a_82_34# GND nfet w=5 l=2
+  ad=0 pd=0 as=0 ps=0
M2135 Vdd datapath_0/register_0/register_one_0[2]/notw datapath_0/register_0/register_one_0[2]/new_latch_0/a_82_52# Vdd pfet w=10 l=2
+  ad=0 pd=0 as=60 ps=32
M2136 GND fsm_0/reg0w datapath_0/register_0/register_one_0[2]/new_latch_1/a_82_52# GND nfet w=5 l=2
+  ad=0 pd=0 as=30 ps=22
M2137 datapath_0/register_0/register_one_0[2]/new_latch_1/a_99_34# datapath_0/register_0/register_one_0[2]/new_latch_1/a_79_32# Vdd Vdd pfet w=10 l=2
+  ad=40 pd=28 as=0 ps=0
M2138 datapath_0/register_0/register_one_0[2]/new_latch_1/a_79_32# datapath_0/wz2 Vdd Vdd pfet w=10 l=2
+  ad=60 pd=32 as=0 ps=0
M2139 datapath_0/register_0/register_one_0[2]/data datapath_0/register_0/register_one_0[2]/new_latch_1/a_82_52# datapath_0/register_0/register_one_0[2]/new_latch_1/a_99_34# Vdd pfet w=10 l=2
+  ad=60 pd=32 as=0 ps=0
M2140 datapath_0/register_0/register_one_0[2]/new_latch_1/a_82_34# datapath_0/register_0/register_one_0[2]/new_latch_1/a_79_32# GND GND nfet w=5 l=2
+  ad=20 pd=18 as=0 ps=0
M2141 datapath_0/register_0/register_one_0[2]/new_latch_1/a_79_32# datapath_0/wz2 GND GND nfet w=5 l=2
+  ad=30 pd=22 as=0 ps=0
M2142 datapath_0/register_0/register_one_0[2]/data fsm_0/reg0w datapath_0/register_0/register_one_0[2]/new_latch_1/a_82_34# GND nfet w=5 l=2
+  ad=30 pd=22 as=0 ps=0
M2143 Vdd fsm_0/reg0w datapath_0/register_0/register_one_0[2]/new_latch_1/a_82_52# Vdd pfet w=10 l=2
+  ad=0 pd=0 as=60 ps=32
M2144 GND fsm_0/reg0r0 datapath_0/register_0/register_one_0[2]/new_latch_2/a_82_52# GND nfet w=5 l=2
+  ad=0 pd=0 as=30 ps=22
M2145 datapath_0/register_0/register_one_0[2]/new_latch_2/a_99_34# datapath_0/register_0/register_one_0[2]/new_latch_2/a_79_32# Vdd Vdd pfet w=10 l=2
+  ad=40 pd=28 as=0 ps=0
M2146 datapath_0/register_0/register_one_0[2]/new_latch_2/a_79_32# datapath_0/register_0/register_one_0[2]/data Vdd Vdd pfet w=10 l=2
+  ad=60 pd=32 as=0 ps=0
M2147 datapath_0/rx2 datapath_0/register_0/register_one_0[2]/new_latch_2/a_82_52# datapath_0/register_0/register_one_0[2]/new_latch_2/a_99_34# Vdd pfet w=10 l=2
+  ad=120 pd=64 as=0 ps=0
M2148 datapath_0/register_0/register_one_0[2]/new_latch_2/a_82_34# datapath_0/register_0/register_one_0[2]/new_latch_2/a_79_32# GND GND nfet w=5 l=2
+  ad=20 pd=18 as=0 ps=0
M2149 datapath_0/register_0/register_one_0[2]/new_latch_2/a_79_32# datapath_0/register_0/register_one_0[2]/data GND GND nfet w=5 l=2
+  ad=30 pd=22 as=0 ps=0
M2150 datapath_0/rx2 fsm_0/reg0r0 datapath_0/register_0/register_one_0[2]/new_latch_2/a_82_34# GND nfet w=5 l=2
+  ad=60 pd=44 as=0 ps=0
M2151 Vdd fsm_0/reg0r0 datapath_0/register_0/register_one_0[2]/new_latch_2/a_82_52# Vdd pfet w=10 l=2
+  ad=0 pd=0 as=60 ps=32
M2152 GND datapath_0/reg1r2 datapath_0/register_0/register_one_0[2]/new_latch_3/a_82_52# GND nfet w=5 l=2
+  ad=0 pd=0 as=30 ps=22
M2153 datapath_0/register_0/register_one_0[2]/new_latch_3/a_99_34# datapath_0/register_0/register_one_0[2]/new_latch_3/a_79_32# Vdd Vdd pfet w=10 l=2
+  ad=40 pd=28 as=0 ps=0
M2154 datapath_0/register_0/register_one_0[2]/new_latch_3/a_79_32# datapath_0/register_0/register_one_0[2]/data Vdd Vdd pfet w=10 l=2
+  ad=60 pd=32 as=0 ps=0
M2155 datapath_0/ry2 datapath_0/register_0/register_one_0[2]/new_latch_3/a_82_52# datapath_0/register_0/register_one_0[2]/new_latch_3/a_99_34# Vdd pfet w=10 l=2
+  ad=120 pd=64 as=0 ps=0
M2156 datapath_0/register_0/register_one_0[2]/new_latch_3/a_82_34# datapath_0/register_0/register_one_0[2]/new_latch_3/a_79_32# GND GND nfet w=5 l=2
+  ad=20 pd=18 as=0 ps=0
M2157 datapath_0/register_0/register_one_0[2]/new_latch_3/a_79_32# datapath_0/register_0/register_one_0[2]/data GND GND nfet w=5 l=2
+  ad=30 pd=22 as=0 ps=0
M2158 datapath_0/ry2 datapath_0/reg1r2 datapath_0/register_0/register_one_0[2]/new_latch_3/a_82_34# GND nfet w=5 l=2
+  ad=60 pd=44 as=0 ps=0
M2159 Vdd datapath_0/reg1r2 datapath_0/register_0/register_one_0[2]/new_latch_3/a_82_52# Vdd pfet w=10 l=2
+  ad=0 pd=0 as=60 ps=32
M2160 datapath_0/register_0/register_one_0[3]/tp1 datapath_0/register_0/register_one_0[3]/inv_0/in GND GND nfet w=5 l=2
+  ad=60 pd=44 as=0 ps=0
M2161 datapath_0/register_0/register_one_0[3]/tp1 datapath_0/register_0/register_one_0[3]/inv_0/in Vdd Vdd pfet w=10 l=2
+  ad=120 pd=64 as=0 ps=0
M2162 datapath_0/register_0/register_one_0[3]/inv_0/in datapath_0/register_0/register_one_0[3]/data GND GND nfet w=5 l=2
+  ad=30 pd=22 as=0 ps=0
M2163 datapath_0/register_0/register_one_0[3]/inv_0/in datapath_0/register_0/register_one_0[3]/data Vdd Vdd pfet w=10 l=2
+  ad=60 pd=32 as=0 ps=0
M2164 datapath_0/register_0/register_one_0[3]/notw fsm_0/reg0w GND GND nfet w=5 l=2
+  ad=30 pd=22 as=0 ps=0
M2165 datapath_0/register_0/register_one_0[3]/notw fsm_0/reg0w Vdd Vdd pfet w=10 l=2
+  ad=60 pd=32 as=0 ps=0
M2166 GND datapath_0/register_0/register_one_0[3]/notw datapath_0/register_0/register_one_0[3]/new_latch_0/a_82_52# GND nfet w=5 l=2
+  ad=0 pd=0 as=30 ps=22
M2167 datapath_0/register_0/register_one_0[3]/new_latch_0/a_99_34# datapath_0/register_0/register_one_0[3]/new_latch_0/a_79_32# Vdd Vdd pfet w=10 l=2
+  ad=40 pd=28 as=0 ps=0
M2168 datapath_0/register_0/register_one_0[3]/new_latch_0/a_79_32# datapath_0/register_0/register_one_0[3]/data Vdd Vdd pfet w=10 l=2
+  ad=60 pd=32 as=0 ps=0
M2169 datapath_0/register_0/register_one_0[3]/tp1 datapath_0/register_0/register_one_0[3]/new_latch_0/a_82_52# datapath_0/register_0/register_one_0[3]/new_latch_0/a_99_34# Vdd pfet w=10 l=2
+  ad=0 pd=0 as=0 ps=0
M2170 datapath_0/register_0/register_one_0[3]/new_latch_0/a_82_34# datapath_0/register_0/register_one_0[3]/new_latch_0/a_79_32# GND GND nfet w=5 l=2
+  ad=20 pd=18 as=0 ps=0
M2171 datapath_0/register_0/register_one_0[3]/new_latch_0/a_79_32# datapath_0/register_0/register_one_0[3]/data GND GND nfet w=5 l=2
+  ad=30 pd=22 as=0 ps=0
M2172 datapath_0/register_0/register_one_0[3]/tp1 datapath_0/register_0/register_one_0[3]/notw datapath_0/register_0/register_one_0[3]/new_latch_0/a_82_34# GND nfet w=5 l=2
+  ad=0 pd=0 as=0 ps=0
M2173 Vdd datapath_0/register_0/register_one_0[3]/notw datapath_0/register_0/register_one_0[3]/new_latch_0/a_82_52# Vdd pfet w=10 l=2
+  ad=0 pd=0 as=60 ps=32
M2174 GND fsm_0/reg0w datapath_0/register_0/register_one_0[3]/new_latch_1/a_82_52# GND nfet w=5 l=2
+  ad=0 pd=0 as=30 ps=22
M2175 datapath_0/register_0/register_one_0[3]/new_latch_1/a_99_34# datapath_0/register_0/register_one_0[3]/new_latch_1/a_79_32# Vdd Vdd pfet w=10 l=2
+  ad=40 pd=28 as=0 ps=0
M2176 datapath_0/register_0/register_one_0[3]/new_latch_1/a_79_32# datapath_0/wz3 Vdd Vdd pfet w=10 l=2
+  ad=60 pd=32 as=0 ps=0
M2177 datapath_0/register_0/register_one_0[3]/data datapath_0/register_0/register_one_0[3]/new_latch_1/a_82_52# datapath_0/register_0/register_one_0[3]/new_latch_1/a_99_34# Vdd pfet w=10 l=2
+  ad=60 pd=32 as=0 ps=0
M2178 datapath_0/register_0/register_one_0[3]/new_latch_1/a_82_34# datapath_0/register_0/register_one_0[3]/new_latch_1/a_79_32# GND GND nfet w=5 l=2
+  ad=20 pd=18 as=0 ps=0
M2179 datapath_0/register_0/register_one_0[3]/new_latch_1/a_79_32# datapath_0/wz3 GND GND nfet w=5 l=2
+  ad=30 pd=22 as=0 ps=0
M2180 datapath_0/register_0/register_one_0[3]/data fsm_0/reg0w datapath_0/register_0/register_one_0[3]/new_latch_1/a_82_34# GND nfet w=5 l=2
+  ad=30 pd=22 as=0 ps=0
M2181 Vdd fsm_0/reg0w datapath_0/register_0/register_one_0[3]/new_latch_1/a_82_52# Vdd pfet w=10 l=2
+  ad=0 pd=0 as=60 ps=32
M2182 GND fsm_0/reg0r0 datapath_0/register_0/register_one_0[3]/new_latch_2/a_82_52# GND nfet w=5 l=2
+  ad=0 pd=0 as=30 ps=22
M2183 datapath_0/register_0/register_one_0[3]/new_latch_2/a_99_34# datapath_0/register_0/register_one_0[3]/new_latch_2/a_79_32# Vdd Vdd pfet w=10 l=2
+  ad=40 pd=28 as=0 ps=0
M2184 datapath_0/register_0/register_one_0[3]/new_latch_2/a_79_32# datapath_0/register_0/register_one_0[3]/data Vdd Vdd pfet w=10 l=2
+  ad=60 pd=32 as=0 ps=0
M2185 datapath_0/rx3 datapath_0/register_0/register_one_0[3]/new_latch_2/a_82_52# datapath_0/register_0/register_one_0[3]/new_latch_2/a_99_34# Vdd pfet w=10 l=2
+  ad=120 pd=64 as=0 ps=0
M2186 datapath_0/register_0/register_one_0[3]/new_latch_2/a_82_34# datapath_0/register_0/register_one_0[3]/new_latch_2/a_79_32# GND GND nfet w=5 l=2
+  ad=20 pd=18 as=0 ps=0
M2187 datapath_0/register_0/register_one_0[3]/new_latch_2/a_79_32# datapath_0/register_0/register_one_0[3]/data GND GND nfet w=5 l=2
+  ad=30 pd=22 as=0 ps=0
M2188 datapath_0/rx3 fsm_0/reg0r0 datapath_0/register_0/register_one_0[3]/new_latch_2/a_82_34# GND nfet w=5 l=2
+  ad=60 pd=44 as=0 ps=0
M2189 Vdd fsm_0/reg0r0 datapath_0/register_0/register_one_0[3]/new_latch_2/a_82_52# Vdd pfet w=10 l=2
+  ad=0 pd=0 as=60 ps=32
M2190 GND datapath_0/reg1r2 datapath_0/register_0/register_one_0[3]/new_latch_3/a_82_52# GND nfet w=5 l=2
+  ad=0 pd=0 as=30 ps=22
M2191 datapath_0/register_0/register_one_0[3]/new_latch_3/a_99_34# datapath_0/register_0/register_one_0[3]/new_latch_3/a_79_32# Vdd Vdd pfet w=10 l=2
+  ad=40 pd=28 as=0 ps=0
M2192 datapath_0/register_0/register_one_0[3]/new_latch_3/a_79_32# datapath_0/register_0/register_one_0[3]/data Vdd Vdd pfet w=10 l=2
+  ad=60 pd=32 as=0 ps=0
M2193 datapath_0/ry3 datapath_0/register_0/register_one_0[3]/new_latch_3/a_82_52# datapath_0/register_0/register_one_0[3]/new_latch_3/a_99_34# Vdd pfet w=10 l=2
+  ad=120 pd=64 as=0 ps=0
M2194 datapath_0/register_0/register_one_0[3]/new_latch_3/a_82_34# datapath_0/register_0/register_one_0[3]/new_latch_3/a_79_32# GND GND nfet w=5 l=2
+  ad=20 pd=18 as=0 ps=0
M2195 datapath_0/register_0/register_one_0[3]/new_latch_3/a_79_32# datapath_0/register_0/register_one_0[3]/data GND GND nfet w=5 l=2
+  ad=30 pd=22 as=0 ps=0
M2196 datapath_0/ry3 datapath_0/reg1r2 datapath_0/register_0/register_one_0[3]/new_latch_3/a_82_34# GND nfet w=5 l=2
+  ad=60 pd=44 as=0 ps=0
M2197 Vdd datapath_0/reg1r2 datapath_0/register_0/register_one_0[3]/new_latch_3/a_82_52# Vdd pfet w=10 l=2
+  ad=0 pd=0 as=60 ps=32
M2198 datapath_0/register_0/register_one_0[4]/tp1 datapath_0/register_0/register_one_0[4]/inv_0/in GND GND nfet w=5 l=2
+  ad=60 pd=44 as=0 ps=0
M2199 datapath_0/register_0/register_one_0[4]/tp1 datapath_0/register_0/register_one_0[4]/inv_0/in Vdd Vdd pfet w=10 l=2
+  ad=120 pd=64 as=0 ps=0
M2200 datapath_0/register_0/register_one_0[4]/inv_0/in datapath_0/register_0/register_one_0[4]/data GND GND nfet w=5 l=2
+  ad=30 pd=22 as=0 ps=0
M2201 datapath_0/register_0/register_one_0[4]/inv_0/in datapath_0/register_0/register_one_0[4]/data Vdd Vdd pfet w=10 l=2
+  ad=60 pd=32 as=0 ps=0
M2202 datapath_0/register_0/register_one_0[4]/notw fsm_0/reg0w GND GND nfet w=5 l=2
+  ad=30 pd=22 as=0 ps=0
M2203 datapath_0/register_0/register_one_0[4]/notw fsm_0/reg0w Vdd Vdd pfet w=10 l=2
+  ad=60 pd=32 as=0 ps=0
M2204 GND datapath_0/register_0/register_one_0[4]/notw datapath_0/register_0/register_one_0[4]/new_latch_0/a_82_52# GND nfet w=5 l=2
+  ad=0 pd=0 as=30 ps=22
M2205 datapath_0/register_0/register_one_0[4]/new_latch_0/a_99_34# datapath_0/register_0/register_one_0[4]/new_latch_0/a_79_32# Vdd Vdd pfet w=10 l=2
+  ad=40 pd=28 as=0 ps=0
M2206 datapath_0/register_0/register_one_0[4]/new_latch_0/a_79_32# datapath_0/register_0/register_one_0[4]/data Vdd Vdd pfet w=10 l=2
+  ad=60 pd=32 as=0 ps=0
M2207 datapath_0/register_0/register_one_0[4]/tp1 datapath_0/register_0/register_one_0[4]/new_latch_0/a_82_52# datapath_0/register_0/register_one_0[4]/new_latch_0/a_99_34# Vdd pfet w=10 l=2
+  ad=0 pd=0 as=0 ps=0
M2208 datapath_0/register_0/register_one_0[4]/new_latch_0/a_82_34# datapath_0/register_0/register_one_0[4]/new_latch_0/a_79_32# GND GND nfet w=5 l=2
+  ad=20 pd=18 as=0 ps=0
M2209 datapath_0/register_0/register_one_0[4]/new_latch_0/a_79_32# datapath_0/register_0/register_one_0[4]/data GND GND nfet w=5 l=2
+  ad=30 pd=22 as=0 ps=0
M2210 datapath_0/register_0/register_one_0[4]/tp1 datapath_0/register_0/register_one_0[4]/notw datapath_0/register_0/register_one_0[4]/new_latch_0/a_82_34# GND nfet w=5 l=2
+  ad=0 pd=0 as=0 ps=0
M2211 Vdd datapath_0/register_0/register_one_0[4]/notw datapath_0/register_0/register_one_0[4]/new_latch_0/a_82_52# Vdd pfet w=10 l=2
+  ad=0 pd=0 as=60 ps=32
M2212 GND fsm_0/reg0w datapath_0/register_0/register_one_0[4]/new_latch_1/a_82_52# GND nfet w=5 l=2
+  ad=0 pd=0 as=30 ps=22
M2213 datapath_0/register_0/register_one_0[4]/new_latch_1/a_99_34# datapath_0/register_0/register_one_0[4]/new_latch_1/a_79_32# Vdd Vdd pfet w=10 l=2
+  ad=40 pd=28 as=0 ps=0
M2214 datapath_0/register_0/register_one_0[4]/new_latch_1/a_79_32# datapath_0/wz4 Vdd Vdd pfet w=10 l=2
+  ad=60 pd=32 as=0 ps=0
M2215 datapath_0/register_0/register_one_0[4]/data datapath_0/register_0/register_one_0[4]/new_latch_1/a_82_52# datapath_0/register_0/register_one_0[4]/new_latch_1/a_99_34# Vdd pfet w=10 l=2
+  ad=60 pd=32 as=0 ps=0
M2216 datapath_0/register_0/register_one_0[4]/new_latch_1/a_82_34# datapath_0/register_0/register_one_0[4]/new_latch_1/a_79_32# GND GND nfet w=5 l=2
+  ad=20 pd=18 as=0 ps=0
M2217 datapath_0/register_0/register_one_0[4]/new_latch_1/a_79_32# datapath_0/wz4 GND GND nfet w=5 l=2
+  ad=30 pd=22 as=0 ps=0
M2218 datapath_0/register_0/register_one_0[4]/data fsm_0/reg0w datapath_0/register_0/register_one_0[4]/new_latch_1/a_82_34# GND nfet w=5 l=2
+  ad=30 pd=22 as=0 ps=0
M2219 Vdd fsm_0/reg0w datapath_0/register_0/register_one_0[4]/new_latch_1/a_82_52# Vdd pfet w=10 l=2
+  ad=0 pd=0 as=60 ps=32
M2220 GND fsm_0/reg0r0 datapath_0/register_0/register_one_0[4]/new_latch_2/a_82_52# GND nfet w=5 l=2
+  ad=0 pd=0 as=30 ps=22
M2221 datapath_0/register_0/register_one_0[4]/new_latch_2/a_99_34# datapath_0/register_0/register_one_0[4]/new_latch_2/a_79_32# Vdd Vdd pfet w=10 l=2
+  ad=40 pd=28 as=0 ps=0
M2222 datapath_0/register_0/register_one_0[4]/new_latch_2/a_79_32# datapath_0/register_0/register_one_0[4]/data Vdd Vdd pfet w=10 l=2
+  ad=60 pd=32 as=0 ps=0
M2223 datapath_0/rx4 datapath_0/register_0/register_one_0[4]/new_latch_2/a_82_52# datapath_0/register_0/register_one_0[4]/new_latch_2/a_99_34# Vdd pfet w=10 l=2
+  ad=120 pd=64 as=0 ps=0
M2224 datapath_0/register_0/register_one_0[4]/new_latch_2/a_82_34# datapath_0/register_0/register_one_0[4]/new_latch_2/a_79_32# GND GND nfet w=5 l=2
+  ad=20 pd=18 as=0 ps=0
M2225 datapath_0/register_0/register_one_0[4]/new_latch_2/a_79_32# datapath_0/register_0/register_one_0[4]/data GND GND nfet w=5 l=2
+  ad=30 pd=22 as=0 ps=0
M2226 datapath_0/rx4 fsm_0/reg0r0 datapath_0/register_0/register_one_0[4]/new_latch_2/a_82_34# GND nfet w=5 l=2
+  ad=60 pd=44 as=0 ps=0
M2227 Vdd fsm_0/reg0r0 datapath_0/register_0/register_one_0[4]/new_latch_2/a_82_52# Vdd pfet w=10 l=2
+  ad=0 pd=0 as=60 ps=32
M2228 GND datapath_0/reg1r2 datapath_0/register_0/register_one_0[4]/new_latch_3/a_82_52# GND nfet w=5 l=2
+  ad=0 pd=0 as=30 ps=22
M2229 datapath_0/register_0/register_one_0[4]/new_latch_3/a_99_34# datapath_0/register_0/register_one_0[4]/new_latch_3/a_79_32# Vdd Vdd pfet w=10 l=2
+  ad=40 pd=28 as=0 ps=0
M2230 datapath_0/register_0/register_one_0[4]/new_latch_3/a_79_32# datapath_0/register_0/register_one_0[4]/data Vdd Vdd pfet w=10 l=2
+  ad=60 pd=32 as=0 ps=0
M2231 datapath_0/ry4 datapath_0/register_0/register_one_0[4]/new_latch_3/a_82_52# datapath_0/register_0/register_one_0[4]/new_latch_3/a_99_34# Vdd pfet w=10 l=2
+  ad=120 pd=64 as=0 ps=0
M2232 datapath_0/register_0/register_one_0[4]/new_latch_3/a_82_34# datapath_0/register_0/register_one_0[4]/new_latch_3/a_79_32# GND GND nfet w=5 l=2
+  ad=20 pd=18 as=0 ps=0
M2233 datapath_0/register_0/register_one_0[4]/new_latch_3/a_79_32# datapath_0/register_0/register_one_0[4]/data GND GND nfet w=5 l=2
+  ad=30 pd=22 as=0 ps=0
M2234 datapath_0/ry4 datapath_0/reg1r2 datapath_0/register_0/register_one_0[4]/new_latch_3/a_82_34# GND nfet w=5 l=2
+  ad=60 pd=44 as=0 ps=0
M2235 Vdd datapath_0/reg1r2 datapath_0/register_0/register_one_0[4]/new_latch_3/a_82_52# Vdd pfet w=10 l=2
+  ad=0 pd=0 as=60 ps=32
M2236 datapath_0/register_0/register_one_0[5]/tp1 datapath_0/register_0/register_one_0[5]/inv_0/in GND GND nfet w=5 l=2
+  ad=60 pd=44 as=0 ps=0
M2237 datapath_0/register_0/register_one_0[5]/tp1 datapath_0/register_0/register_one_0[5]/inv_0/in Vdd Vdd pfet w=10 l=2
+  ad=120 pd=64 as=0 ps=0
M2238 datapath_0/register_0/register_one_0[5]/inv_0/in datapath_0/register_0/register_one_0[5]/data GND GND nfet w=5 l=2
+  ad=30 pd=22 as=0 ps=0
M2239 datapath_0/register_0/register_one_0[5]/inv_0/in datapath_0/register_0/register_one_0[5]/data Vdd Vdd pfet w=10 l=2
+  ad=60 pd=32 as=0 ps=0
M2240 datapath_0/register_0/register_one_0[5]/notw fsm_0/reg0w GND GND nfet w=5 l=2
+  ad=30 pd=22 as=0 ps=0
M2241 datapath_0/register_0/register_one_0[5]/notw fsm_0/reg0w Vdd Vdd pfet w=10 l=2
+  ad=60 pd=32 as=0 ps=0
M2242 GND datapath_0/register_0/register_one_0[5]/notw datapath_0/register_0/register_one_0[5]/new_latch_0/a_82_52# GND nfet w=5 l=2
+  ad=0 pd=0 as=30 ps=22
M2243 datapath_0/register_0/register_one_0[5]/new_latch_0/a_99_34# datapath_0/register_0/register_one_0[5]/new_latch_0/a_79_32# Vdd Vdd pfet w=10 l=2
+  ad=40 pd=28 as=0 ps=0
M2244 datapath_0/register_0/register_one_0[5]/new_latch_0/a_79_32# datapath_0/register_0/register_one_0[5]/data Vdd Vdd pfet w=10 l=2
+  ad=60 pd=32 as=0 ps=0
M2245 datapath_0/register_0/register_one_0[5]/tp1 datapath_0/register_0/register_one_0[5]/new_latch_0/a_82_52# datapath_0/register_0/register_one_0[5]/new_latch_0/a_99_34# Vdd pfet w=10 l=2
+  ad=0 pd=0 as=0 ps=0
M2246 datapath_0/register_0/register_one_0[5]/new_latch_0/a_82_34# datapath_0/register_0/register_one_0[5]/new_latch_0/a_79_32# GND GND nfet w=5 l=2
+  ad=20 pd=18 as=0 ps=0
M2247 datapath_0/register_0/register_one_0[5]/new_latch_0/a_79_32# datapath_0/register_0/register_one_0[5]/data GND GND nfet w=5 l=2
+  ad=30 pd=22 as=0 ps=0
M2248 datapath_0/register_0/register_one_0[5]/tp1 datapath_0/register_0/register_one_0[5]/notw datapath_0/register_0/register_one_0[5]/new_latch_0/a_82_34# GND nfet w=5 l=2
+  ad=0 pd=0 as=0 ps=0
M2249 Vdd datapath_0/register_0/register_one_0[5]/notw datapath_0/register_0/register_one_0[5]/new_latch_0/a_82_52# Vdd pfet w=10 l=2
+  ad=0 pd=0 as=60 ps=32
M2250 GND fsm_0/reg0w datapath_0/register_0/register_one_0[5]/new_latch_1/a_82_52# GND nfet w=5 l=2
+  ad=0 pd=0 as=30 ps=22
M2251 datapath_0/register_0/register_one_0[5]/new_latch_1/a_99_34# datapath_0/register_0/register_one_0[5]/new_latch_1/a_79_32# Vdd Vdd pfet w=10 l=2
+  ad=40 pd=28 as=0 ps=0
M2252 datapath_0/register_0/register_one_0[5]/new_latch_1/a_79_32# datapath_0/wz5 Vdd Vdd pfet w=10 l=2
+  ad=60 pd=32 as=0 ps=0
M2253 datapath_0/register_0/register_one_0[5]/data datapath_0/register_0/register_one_0[5]/new_latch_1/a_82_52# datapath_0/register_0/register_one_0[5]/new_latch_1/a_99_34# Vdd pfet w=10 l=2
+  ad=60 pd=32 as=0 ps=0
M2254 datapath_0/register_0/register_one_0[5]/new_latch_1/a_82_34# datapath_0/register_0/register_one_0[5]/new_latch_1/a_79_32# GND GND nfet w=5 l=2
+  ad=20 pd=18 as=0 ps=0
M2255 datapath_0/register_0/register_one_0[5]/new_latch_1/a_79_32# datapath_0/wz5 GND GND nfet w=5 l=2
+  ad=30 pd=22 as=0 ps=0
M2256 datapath_0/register_0/register_one_0[5]/data fsm_0/reg0w datapath_0/register_0/register_one_0[5]/new_latch_1/a_82_34# GND nfet w=5 l=2
+  ad=30 pd=22 as=0 ps=0
M2257 Vdd fsm_0/reg0w datapath_0/register_0/register_one_0[5]/new_latch_1/a_82_52# Vdd pfet w=10 l=2
+  ad=0 pd=0 as=60 ps=32
M2258 GND fsm_0/reg0r0 datapath_0/register_0/register_one_0[5]/new_latch_2/a_82_52# GND nfet w=5 l=2
+  ad=0 pd=0 as=30 ps=22
M2259 datapath_0/register_0/register_one_0[5]/new_latch_2/a_99_34# datapath_0/register_0/register_one_0[5]/new_latch_2/a_79_32# Vdd Vdd pfet w=10 l=2
+  ad=40 pd=28 as=0 ps=0
M2260 datapath_0/register_0/register_one_0[5]/new_latch_2/a_79_32# datapath_0/register_0/register_one_0[5]/data Vdd Vdd pfet w=10 l=2
+  ad=60 pd=32 as=0 ps=0
M2261 datapath_0/rx5 datapath_0/register_0/register_one_0[5]/new_latch_2/a_82_52# datapath_0/register_0/register_one_0[5]/new_latch_2/a_99_34# Vdd pfet w=10 l=2
+  ad=120 pd=64 as=0 ps=0
M2262 datapath_0/register_0/register_one_0[5]/new_latch_2/a_82_34# datapath_0/register_0/register_one_0[5]/new_latch_2/a_79_32# GND GND nfet w=5 l=2
+  ad=20 pd=18 as=0 ps=0
M2263 datapath_0/register_0/register_one_0[5]/new_latch_2/a_79_32# datapath_0/register_0/register_one_0[5]/data GND GND nfet w=5 l=2
+  ad=30 pd=22 as=0 ps=0
M2264 datapath_0/rx5 fsm_0/reg0r0 datapath_0/register_0/register_one_0[5]/new_latch_2/a_82_34# GND nfet w=5 l=2
+  ad=60 pd=44 as=0 ps=0
M2265 Vdd fsm_0/reg0r0 datapath_0/register_0/register_one_0[5]/new_latch_2/a_82_52# Vdd pfet w=10 l=2
+  ad=0 pd=0 as=60 ps=32
M2266 GND datapath_0/reg1r2 datapath_0/register_0/register_one_0[5]/new_latch_3/a_82_52# GND nfet w=5 l=2
+  ad=0 pd=0 as=30 ps=22
M2267 datapath_0/register_0/register_one_0[5]/new_latch_3/a_99_34# datapath_0/register_0/register_one_0[5]/new_latch_3/a_79_32# Vdd Vdd pfet w=10 l=2
+  ad=40 pd=28 as=0 ps=0
M2268 datapath_0/register_0/register_one_0[5]/new_latch_3/a_79_32# datapath_0/register_0/register_one_0[5]/data Vdd Vdd pfet w=10 l=2
+  ad=60 pd=32 as=0 ps=0
M2269 datapath_0/ry5 datapath_0/register_0/register_one_0[5]/new_latch_3/a_82_52# datapath_0/register_0/register_one_0[5]/new_latch_3/a_99_34# Vdd pfet w=10 l=2
+  ad=120 pd=64 as=0 ps=0
M2270 datapath_0/register_0/register_one_0[5]/new_latch_3/a_82_34# datapath_0/register_0/register_one_0[5]/new_latch_3/a_79_32# GND GND nfet w=5 l=2
+  ad=20 pd=18 as=0 ps=0
M2271 datapath_0/register_0/register_one_0[5]/new_latch_3/a_79_32# datapath_0/register_0/register_one_0[5]/data GND GND nfet w=5 l=2
+  ad=30 pd=22 as=0 ps=0
M2272 datapath_0/ry5 datapath_0/reg1r2 datapath_0/register_0/register_one_0[5]/new_latch_3/a_82_34# GND nfet w=5 l=2
+  ad=60 pd=44 as=0 ps=0
M2273 Vdd datapath_0/reg1r2 datapath_0/register_0/register_one_0[5]/new_latch_3/a_82_52# Vdd pfet w=10 l=2
+  ad=0 pd=0 as=60 ps=32
M2274 datapath_0/register_0/register_one_0[6]/tp1 datapath_0/register_0/register_one_0[6]/inv_0/in GND GND nfet w=5 l=2
+  ad=60 pd=44 as=0 ps=0
M2275 datapath_0/register_0/register_one_0[6]/tp1 datapath_0/register_0/register_one_0[6]/inv_0/in Vdd Vdd pfet w=10 l=2
+  ad=120 pd=64 as=0 ps=0
M2276 datapath_0/register_0/register_one_0[6]/inv_0/in datapath_0/register_0/register_one_0[6]/data GND GND nfet w=5 l=2
+  ad=30 pd=22 as=0 ps=0
M2277 datapath_0/register_0/register_one_0[6]/inv_0/in datapath_0/register_0/register_one_0[6]/data Vdd Vdd pfet w=10 l=2
+  ad=60 pd=32 as=0 ps=0
M2278 datapath_0/register_0/register_one_0[6]/notw fsm_0/reg0w GND GND nfet w=5 l=2
+  ad=30 pd=22 as=0 ps=0
M2279 datapath_0/register_0/register_one_0[6]/notw fsm_0/reg0w Vdd Vdd pfet w=10 l=2
+  ad=60 pd=32 as=0 ps=0
M2280 GND datapath_0/register_0/register_one_0[6]/notw datapath_0/register_0/register_one_0[6]/new_latch_0/a_82_52# GND nfet w=5 l=2
+  ad=0 pd=0 as=30 ps=22
M2281 datapath_0/register_0/register_one_0[6]/new_latch_0/a_99_34# datapath_0/register_0/register_one_0[6]/new_latch_0/a_79_32# Vdd Vdd pfet w=10 l=2
+  ad=40 pd=28 as=0 ps=0
M2282 datapath_0/register_0/register_one_0[6]/new_latch_0/a_79_32# datapath_0/register_0/register_one_0[6]/data Vdd Vdd pfet w=10 l=2
+  ad=60 pd=32 as=0 ps=0
M2283 datapath_0/register_0/register_one_0[6]/tp1 datapath_0/register_0/register_one_0[6]/new_latch_0/a_82_52# datapath_0/register_0/register_one_0[6]/new_latch_0/a_99_34# Vdd pfet w=10 l=2
+  ad=0 pd=0 as=0 ps=0
M2284 datapath_0/register_0/register_one_0[6]/new_latch_0/a_82_34# datapath_0/register_0/register_one_0[6]/new_latch_0/a_79_32# GND GND nfet w=5 l=2
+  ad=20 pd=18 as=0 ps=0
M2285 datapath_0/register_0/register_one_0[6]/new_latch_0/a_79_32# datapath_0/register_0/register_one_0[6]/data GND GND nfet w=5 l=2
+  ad=30 pd=22 as=0 ps=0
M2286 datapath_0/register_0/register_one_0[6]/tp1 datapath_0/register_0/register_one_0[6]/notw datapath_0/register_0/register_one_0[6]/new_latch_0/a_82_34# GND nfet w=5 l=2
+  ad=0 pd=0 as=0 ps=0
M2287 Vdd datapath_0/register_0/register_one_0[6]/notw datapath_0/register_0/register_one_0[6]/new_latch_0/a_82_52# Vdd pfet w=10 l=2
+  ad=0 pd=0 as=60 ps=32
M2288 GND fsm_0/reg0w datapath_0/register_0/register_one_0[6]/new_latch_1/a_82_52# GND nfet w=5 l=2
+  ad=0 pd=0 as=30 ps=22
M2289 datapath_0/register_0/register_one_0[6]/new_latch_1/a_99_34# datapath_0/register_0/register_one_0[6]/new_latch_1/a_79_32# Vdd Vdd pfet w=10 l=2
+  ad=40 pd=28 as=0 ps=0
M2290 datapath_0/register_0/register_one_0[6]/new_latch_1/a_79_32# datapath_0/wz6 Vdd Vdd pfet w=10 l=2
+  ad=60 pd=32 as=0 ps=0
M2291 datapath_0/register_0/register_one_0[6]/data datapath_0/register_0/register_one_0[6]/new_latch_1/a_82_52# datapath_0/register_0/register_one_0[6]/new_latch_1/a_99_34# Vdd pfet w=10 l=2
+  ad=60 pd=32 as=0 ps=0
M2292 datapath_0/register_0/register_one_0[6]/new_latch_1/a_82_34# datapath_0/register_0/register_one_0[6]/new_latch_1/a_79_32# GND GND nfet w=5 l=2
+  ad=20 pd=18 as=0 ps=0
M2293 datapath_0/register_0/register_one_0[6]/new_latch_1/a_79_32# datapath_0/wz6 GND GND nfet w=5 l=2
+  ad=30 pd=22 as=0 ps=0
M2294 datapath_0/register_0/register_one_0[6]/data fsm_0/reg0w datapath_0/register_0/register_one_0[6]/new_latch_1/a_82_34# GND nfet w=5 l=2
+  ad=30 pd=22 as=0 ps=0
M2295 Vdd fsm_0/reg0w datapath_0/register_0/register_one_0[6]/new_latch_1/a_82_52# Vdd pfet w=10 l=2
+  ad=0 pd=0 as=60 ps=32
M2296 GND fsm_0/reg0r0 datapath_0/register_0/register_one_0[6]/new_latch_2/a_82_52# GND nfet w=5 l=2
+  ad=0 pd=0 as=30 ps=22
M2297 datapath_0/register_0/register_one_0[6]/new_latch_2/a_99_34# datapath_0/register_0/register_one_0[6]/new_latch_2/a_79_32# Vdd Vdd pfet w=10 l=2
+  ad=40 pd=28 as=0 ps=0
M2298 datapath_0/register_0/register_one_0[6]/new_latch_2/a_79_32# datapath_0/register_0/register_one_0[6]/data Vdd Vdd pfet w=10 l=2
+  ad=60 pd=32 as=0 ps=0
M2299 datapath_0/rx6 datapath_0/register_0/register_one_0[6]/new_latch_2/a_82_52# datapath_0/register_0/register_one_0[6]/new_latch_2/a_99_34# Vdd pfet w=10 l=2
+  ad=120 pd=64 as=0 ps=0
M2300 datapath_0/register_0/register_one_0[6]/new_latch_2/a_82_34# datapath_0/register_0/register_one_0[6]/new_latch_2/a_79_32# GND GND nfet w=5 l=2
+  ad=20 pd=18 as=0 ps=0
M2301 datapath_0/register_0/register_one_0[6]/new_latch_2/a_79_32# datapath_0/register_0/register_one_0[6]/data GND GND nfet w=5 l=2
+  ad=30 pd=22 as=0 ps=0
M2302 datapath_0/rx6 fsm_0/reg0r0 datapath_0/register_0/register_one_0[6]/new_latch_2/a_82_34# GND nfet w=5 l=2
+  ad=60 pd=44 as=0 ps=0
M2303 Vdd fsm_0/reg0r0 datapath_0/register_0/register_one_0[6]/new_latch_2/a_82_52# Vdd pfet w=10 l=2
+  ad=0 pd=0 as=60 ps=32
M2304 GND datapath_0/reg1r2 datapath_0/register_0/register_one_0[6]/new_latch_3/a_82_52# GND nfet w=5 l=2
+  ad=0 pd=0 as=30 ps=22
M2305 datapath_0/register_0/register_one_0[6]/new_latch_3/a_99_34# datapath_0/register_0/register_one_0[6]/new_latch_3/a_79_32# Vdd Vdd pfet w=10 l=2
+  ad=40 pd=28 as=0 ps=0
M2306 datapath_0/register_0/register_one_0[6]/new_latch_3/a_79_32# datapath_0/register_0/register_one_0[6]/data Vdd Vdd pfet w=10 l=2
+  ad=60 pd=32 as=0 ps=0
M2307 datapath_0/ry6 datapath_0/register_0/register_one_0[6]/new_latch_3/a_82_52# datapath_0/register_0/register_one_0[6]/new_latch_3/a_99_34# Vdd pfet w=10 l=2
+  ad=120 pd=64 as=0 ps=0
M2308 datapath_0/register_0/register_one_0[6]/new_latch_3/a_82_34# datapath_0/register_0/register_one_0[6]/new_latch_3/a_79_32# GND GND nfet w=5 l=2
+  ad=20 pd=18 as=0 ps=0
M2309 datapath_0/register_0/register_one_0[6]/new_latch_3/a_79_32# datapath_0/register_0/register_one_0[6]/data GND GND nfet w=5 l=2
+  ad=30 pd=22 as=0 ps=0
M2310 datapath_0/ry6 datapath_0/reg1r2 datapath_0/register_0/register_one_0[6]/new_latch_3/a_82_34# GND nfet w=5 l=2
+  ad=60 pd=44 as=0 ps=0
M2311 Vdd datapath_0/reg1r2 datapath_0/register_0/register_one_0[6]/new_latch_3/a_82_52# Vdd pfet w=10 l=2
+  ad=0 pd=0 as=60 ps=32
M2312 datapath_0/register_0/register_one_0[7]/tp1 datapath_0/register_0/register_one_0[7]/inv_0/in GND GND nfet w=5 l=2
+  ad=60 pd=44 as=0 ps=0
M2313 datapath_0/register_0/register_one_0[7]/tp1 datapath_0/register_0/register_one_0[7]/inv_0/in Vdd Vdd pfet w=10 l=2
+  ad=120 pd=64 as=0 ps=0
M2314 datapath_0/register_0/register_one_0[7]/inv_0/in datapath_0/register_0/register_one_0[7]/data GND GND nfet w=5 l=2
+  ad=30 pd=22 as=0 ps=0
M2315 datapath_0/register_0/register_one_0[7]/inv_0/in datapath_0/register_0/register_one_0[7]/data Vdd Vdd pfet w=10 l=2
+  ad=60 pd=32 as=0 ps=0
M2316 datapath_0/register_0/register_one_0[7]/notw fsm_0/reg0w GND GND nfet w=5 l=2
+  ad=30 pd=22 as=0 ps=0
M2317 datapath_0/register_0/register_one_0[7]/notw fsm_0/reg0w Vdd Vdd pfet w=10 l=2
+  ad=60 pd=32 as=0 ps=0
M2318 GND datapath_0/register_0/register_one_0[7]/notw datapath_0/register_0/register_one_0[7]/new_latch_0/a_82_52# GND nfet w=5 l=2
+  ad=0 pd=0 as=30 ps=22
M2319 datapath_0/register_0/register_one_0[7]/new_latch_0/a_99_34# datapath_0/register_0/register_one_0[7]/new_latch_0/a_79_32# Vdd Vdd pfet w=10 l=2
+  ad=40 pd=28 as=0 ps=0
M2320 datapath_0/register_0/register_one_0[7]/new_latch_0/a_79_32# datapath_0/register_0/register_one_0[7]/data Vdd Vdd pfet w=10 l=2
+  ad=60 pd=32 as=0 ps=0
M2321 datapath_0/register_0/register_one_0[7]/tp1 datapath_0/register_0/register_one_0[7]/new_latch_0/a_82_52# datapath_0/register_0/register_one_0[7]/new_latch_0/a_99_34# Vdd pfet w=10 l=2
+  ad=0 pd=0 as=0 ps=0
M2322 datapath_0/register_0/register_one_0[7]/new_latch_0/a_82_34# datapath_0/register_0/register_one_0[7]/new_latch_0/a_79_32# GND GND nfet w=5 l=2
+  ad=20 pd=18 as=0 ps=0
M2323 datapath_0/register_0/register_one_0[7]/new_latch_0/a_79_32# datapath_0/register_0/register_one_0[7]/data GND GND nfet w=5 l=2
+  ad=30 pd=22 as=0 ps=0
M2324 datapath_0/register_0/register_one_0[7]/tp1 datapath_0/register_0/register_one_0[7]/notw datapath_0/register_0/register_one_0[7]/new_latch_0/a_82_34# GND nfet w=5 l=2
+  ad=0 pd=0 as=0 ps=0
M2325 Vdd datapath_0/register_0/register_one_0[7]/notw datapath_0/register_0/register_one_0[7]/new_latch_0/a_82_52# Vdd pfet w=10 l=2
+  ad=0 pd=0 as=60 ps=32
M2326 GND fsm_0/reg0w datapath_0/register_0/register_one_0[7]/new_latch_1/a_82_52# GND nfet w=5 l=2
+  ad=0 pd=0 as=30 ps=22
M2327 datapath_0/register_0/register_one_0[7]/new_latch_1/a_99_34# datapath_0/register_0/register_one_0[7]/new_latch_1/a_79_32# Vdd Vdd pfet w=10 l=2
+  ad=40 pd=28 as=0 ps=0
M2328 datapath_0/register_0/register_one_0[7]/new_latch_1/a_79_32# datapath_0/wz7 Vdd Vdd pfet w=10 l=2
+  ad=60 pd=32 as=0 ps=0
M2329 datapath_0/register_0/register_one_0[7]/data datapath_0/register_0/register_one_0[7]/new_latch_1/a_82_52# datapath_0/register_0/register_one_0[7]/new_latch_1/a_99_34# Vdd pfet w=10 l=2
+  ad=60 pd=32 as=0 ps=0
M2330 datapath_0/register_0/register_one_0[7]/new_latch_1/a_82_34# datapath_0/register_0/register_one_0[7]/new_latch_1/a_79_32# GND GND nfet w=5 l=2
+  ad=20 pd=18 as=0 ps=0
M2331 datapath_0/register_0/register_one_0[7]/new_latch_1/a_79_32# datapath_0/wz7 GND GND nfet w=5 l=2
+  ad=30 pd=22 as=0 ps=0
M2332 datapath_0/register_0/register_one_0[7]/data fsm_0/reg0w datapath_0/register_0/register_one_0[7]/new_latch_1/a_82_34# GND nfet w=5 l=2
+  ad=30 pd=22 as=0 ps=0
M2333 Vdd fsm_0/reg0w datapath_0/register_0/register_one_0[7]/new_latch_1/a_82_52# Vdd pfet w=10 l=2
+  ad=0 pd=0 as=60 ps=32
M2334 GND fsm_0/reg0r0 datapath_0/register_0/register_one_0[7]/new_latch_2/a_82_52# GND nfet w=5 l=2
+  ad=0 pd=0 as=30 ps=22
M2335 datapath_0/register_0/register_one_0[7]/new_latch_2/a_99_34# datapath_0/register_0/register_one_0[7]/new_latch_2/a_79_32# Vdd Vdd pfet w=10 l=2
+  ad=40 pd=28 as=0 ps=0
M2336 datapath_0/register_0/register_one_0[7]/new_latch_2/a_79_32# datapath_0/register_0/register_one_0[7]/data Vdd Vdd pfet w=10 l=2
+  ad=60 pd=32 as=0 ps=0
M2337 datapath_0/rx7 datapath_0/register_0/register_one_0[7]/new_latch_2/a_82_52# datapath_0/register_0/register_one_0[7]/new_latch_2/a_99_34# Vdd pfet w=10 l=2
+  ad=120 pd=64 as=0 ps=0
M2338 datapath_0/register_0/register_one_0[7]/new_latch_2/a_82_34# datapath_0/register_0/register_one_0[7]/new_latch_2/a_79_32# GND GND nfet w=5 l=2
+  ad=20 pd=18 as=0 ps=0
M2339 datapath_0/register_0/register_one_0[7]/new_latch_2/a_79_32# datapath_0/register_0/register_one_0[7]/data GND GND nfet w=5 l=2
+  ad=30 pd=22 as=0 ps=0
M2340 datapath_0/rx7 fsm_0/reg0r0 datapath_0/register_0/register_one_0[7]/new_latch_2/a_82_34# GND nfet w=5 l=2
+  ad=60 pd=44 as=0 ps=0
M2341 Vdd fsm_0/reg0r0 datapath_0/register_0/register_one_0[7]/new_latch_2/a_82_52# Vdd pfet w=10 l=2
+  ad=0 pd=0 as=60 ps=32
M2342 GND datapath_0/reg1r2 datapath_0/register_0/register_one_0[7]/new_latch_3/a_82_52# GND nfet w=5 l=2
+  ad=0 pd=0 as=30 ps=22
M2343 datapath_0/register_0/register_one_0[7]/new_latch_3/a_99_34# datapath_0/register_0/register_one_0[7]/new_latch_3/a_79_32# Vdd Vdd pfet w=10 l=2
+  ad=40 pd=28 as=0 ps=0
M2344 datapath_0/register_0/register_one_0[7]/new_latch_3/a_79_32# datapath_0/register_0/register_one_0[7]/data Vdd Vdd pfet w=10 l=2
+  ad=60 pd=32 as=0 ps=0
M2345 datapath_0/ry7 datapath_0/register_0/register_one_0[7]/new_latch_3/a_82_52# datapath_0/register_0/register_one_0[7]/new_latch_3/a_99_34# Vdd pfet w=10 l=2
+  ad=120 pd=64 as=0 ps=0
M2346 datapath_0/register_0/register_one_0[7]/new_latch_3/a_82_34# datapath_0/register_0/register_one_0[7]/new_latch_3/a_79_32# GND GND nfet w=5 l=2
+  ad=20 pd=18 as=0 ps=0
M2347 datapath_0/register_0/register_one_0[7]/new_latch_3/a_79_32# datapath_0/register_0/register_one_0[7]/data GND GND nfet w=5 l=2
+  ad=30 pd=22 as=0 ps=0
M2348 datapath_0/ry7 datapath_0/reg1r2 datapath_0/register_0/register_one_0[7]/new_latch_3/a_82_34# GND nfet w=5 l=2
+  ad=60 pd=44 as=0 ps=0
M2349 Vdd datapath_0/reg1r2 datapath_0/register_0/register_one_0[7]/new_latch_3/a_82_52# Vdd pfet w=10 l=2
+  ad=0 pd=0 as=60 ps=32
M2350 datapath_0/register_1/register_one_0[0]/tp1 datapath_0/register_1/register_one_0[0]/inv_0/in GND GND nfet w=5 l=2
+  ad=60 pd=44 as=0 ps=0
M2351 datapath_0/register_1/register_one_0[0]/tp1 datapath_0/register_1/register_one_0[0]/inv_0/in Vdd Vdd pfet w=10 l=2
+  ad=120 pd=64 as=0 ps=0
M2352 datapath_0/register_1/register_one_0[0]/inv_0/in datapath_0/register_1/register_one_0[0]/data GND GND nfet w=5 l=2
+  ad=30 pd=22 as=0 ps=0
M2353 datapath_0/register_1/register_one_0[0]/inv_0/in datapath_0/register_1/register_one_0[0]/data Vdd Vdd pfet w=10 l=2
+  ad=60 pd=32 as=0 ps=0
M2354 datapath_0/register_1/register_one_0[0]/notw fsm_0/reg1w GND GND nfet w=5 l=2
+  ad=30 pd=22 as=0 ps=0
M2355 datapath_0/register_1/register_one_0[0]/notw fsm_0/reg1w Vdd Vdd pfet w=10 l=2
+  ad=60 pd=32 as=0 ps=0
M2356 GND datapath_0/register_1/register_one_0[0]/notw datapath_0/register_1/register_one_0[0]/new_latch_0/a_82_52# GND nfet w=5 l=2
+  ad=0 pd=0 as=30 ps=22
M2357 datapath_0/register_1/register_one_0[0]/new_latch_0/a_99_34# datapath_0/register_1/register_one_0[0]/new_latch_0/a_79_32# Vdd Vdd pfet w=10 l=2
+  ad=40 pd=28 as=0 ps=0
M2358 datapath_0/register_1/register_one_0[0]/new_latch_0/a_79_32# datapath_0/register_1/register_one_0[0]/data Vdd Vdd pfet w=10 l=2
+  ad=60 pd=32 as=0 ps=0
M2359 datapath_0/register_1/register_one_0[0]/tp1 datapath_0/register_1/register_one_0[0]/new_latch_0/a_82_52# datapath_0/register_1/register_one_0[0]/new_latch_0/a_99_34# Vdd pfet w=10 l=2
+  ad=0 pd=0 as=0 ps=0
M2360 datapath_0/register_1/register_one_0[0]/new_latch_0/a_82_34# datapath_0/register_1/register_one_0[0]/new_latch_0/a_79_32# GND GND nfet w=5 l=2
+  ad=20 pd=18 as=0 ps=0
M2361 datapath_0/register_1/register_one_0[0]/new_latch_0/a_79_32# datapath_0/register_1/register_one_0[0]/data GND GND nfet w=5 l=2
+  ad=30 pd=22 as=0 ps=0
M2362 datapath_0/register_1/register_one_0[0]/tp1 datapath_0/register_1/register_one_0[0]/notw datapath_0/register_1/register_one_0[0]/new_latch_0/a_82_34# GND nfet w=5 l=2
+  ad=0 pd=0 as=0 ps=0
M2363 Vdd datapath_0/register_1/register_one_0[0]/notw datapath_0/register_1/register_one_0[0]/new_latch_0/a_82_52# Vdd pfet w=10 l=2
+  ad=0 pd=0 as=60 ps=32
M2364 GND fsm_0/reg1w datapath_0/register_1/register_one_0[0]/new_latch_1/a_82_52# GND nfet w=5 l=2
+  ad=0 pd=0 as=30 ps=22
M2365 datapath_0/register_1/register_one_0[0]/new_latch_1/a_99_34# datapath_0/register_1/register_one_0[0]/new_latch_1/a_79_32# Vdd Vdd pfet w=10 l=2
+  ad=40 pd=28 as=0 ps=0
M2366 datapath_0/register_1/register_one_0[0]/new_latch_1/a_79_32# datapath_0/wz0 Vdd Vdd pfet w=10 l=2
+  ad=60 pd=32 as=0 ps=0
M2367 datapath_0/register_1/register_one_0[0]/data datapath_0/register_1/register_one_0[0]/new_latch_1/a_82_52# datapath_0/register_1/register_one_0[0]/new_latch_1/a_99_34# Vdd pfet w=10 l=2
+  ad=60 pd=32 as=0 ps=0
M2368 datapath_0/register_1/register_one_0[0]/new_latch_1/a_82_34# datapath_0/register_1/register_one_0[0]/new_latch_1/a_79_32# GND GND nfet w=5 l=2
+  ad=20 pd=18 as=0 ps=0
M2369 datapath_0/register_1/register_one_0[0]/new_latch_1/a_79_32# datapath_0/wz0 GND GND nfet w=5 l=2
+  ad=30 pd=22 as=0 ps=0
M2370 datapath_0/register_1/register_one_0[0]/data fsm_0/reg1w datapath_0/register_1/register_one_0[0]/new_latch_1/a_82_34# GND nfet w=5 l=2
+  ad=30 pd=22 as=0 ps=0
M2371 Vdd fsm_0/reg1w datapath_0/register_1/register_one_0[0]/new_latch_1/a_82_52# Vdd pfet w=10 l=2
+  ad=0 pd=0 as=60 ps=32
M2372 GND datapath_0/reg2r1 datapath_0/register_1/register_one_0[0]/new_latch_2/a_82_52# GND nfet w=5 l=2
+  ad=0 pd=0 as=30 ps=22
M2373 datapath_0/register_1/register_one_0[0]/new_latch_2/a_99_34# datapath_0/register_1/register_one_0[0]/new_latch_2/a_79_32# Vdd Vdd pfet w=10 l=2
+  ad=40 pd=28 as=0 ps=0
M2374 datapath_0/register_1/register_one_0[0]/new_latch_2/a_79_32# datapath_0/register_1/register_one_0[0]/data Vdd Vdd pfet w=10 l=2
+  ad=60 pd=32 as=0 ps=0
M2375 datapath_0/rx0 datapath_0/register_1/register_one_0[0]/new_latch_2/a_82_52# datapath_0/register_1/register_one_0[0]/new_latch_2/a_99_34# Vdd pfet w=10 l=2
+  ad=0 pd=0 as=0 ps=0
M2376 datapath_0/register_1/register_one_0[0]/new_latch_2/a_82_34# datapath_0/register_1/register_one_0[0]/new_latch_2/a_79_32# GND GND nfet w=5 l=2
+  ad=20 pd=18 as=0 ps=0
M2377 datapath_0/register_1/register_one_0[0]/new_latch_2/a_79_32# datapath_0/register_1/register_one_0[0]/data GND GND nfet w=5 l=2
+  ad=30 pd=22 as=0 ps=0
M2378 datapath_0/rx0 datapath_0/reg2r1 datapath_0/register_1/register_one_0[0]/new_latch_2/a_82_34# GND nfet w=5 l=2
+  ad=0 pd=0 as=0 ps=0
M2379 Vdd datapath_0/reg2r1 datapath_0/register_1/register_one_0[0]/new_latch_2/a_82_52# Vdd pfet w=10 l=2
+  ad=0 pd=0 as=60 ps=32
M2380 GND fsm_0/reg1r1 datapath_0/register_1/register_one_0[0]/new_latch_3/a_82_52# GND nfet w=5 l=2
+  ad=0 pd=0 as=30 ps=22
M2381 datapath_0/register_1/register_one_0[0]/new_latch_3/a_99_34# datapath_0/register_1/register_one_0[0]/new_latch_3/a_79_32# Vdd Vdd pfet w=10 l=2
+  ad=40 pd=28 as=0 ps=0
M2382 datapath_0/register_1/register_one_0[0]/new_latch_3/a_79_32# datapath_0/register_1/register_one_0[0]/data Vdd Vdd pfet w=10 l=2
+  ad=60 pd=32 as=0 ps=0
M2383 datapath_0/ry0 datapath_0/register_1/register_one_0[0]/new_latch_3/a_82_52# datapath_0/register_1/register_one_0[0]/new_latch_3/a_99_34# Vdd pfet w=10 l=2
+  ad=0 pd=0 as=0 ps=0
M2384 datapath_0/register_1/register_one_0[0]/new_latch_3/a_82_34# datapath_0/register_1/register_one_0[0]/new_latch_3/a_79_32# GND GND nfet w=5 l=2
+  ad=20 pd=18 as=0 ps=0
M2385 datapath_0/register_1/register_one_0[0]/new_latch_3/a_79_32# datapath_0/register_1/register_one_0[0]/data GND GND nfet w=5 l=2
+  ad=30 pd=22 as=0 ps=0
M2386 datapath_0/ry0 fsm_0/reg1r1 datapath_0/register_1/register_one_0[0]/new_latch_3/a_82_34# GND nfet w=5 l=2
+  ad=0 pd=0 as=0 ps=0
M2387 Vdd fsm_0/reg1r1 datapath_0/register_1/register_one_0[0]/new_latch_3/a_82_52# Vdd pfet w=10 l=2
+  ad=0 pd=0 as=60 ps=32
M2388 datapath_0/register_1/register_one_0[1]/tp1 datapath_0/register_1/register_one_0[1]/inv_0/in GND GND nfet w=5 l=2
+  ad=60 pd=44 as=0 ps=0
M2389 datapath_0/register_1/register_one_0[1]/tp1 datapath_0/register_1/register_one_0[1]/inv_0/in Vdd Vdd pfet w=10 l=2
+  ad=120 pd=64 as=0 ps=0
M2390 datapath_0/register_1/register_one_0[1]/inv_0/in datapath_0/register_1/register_one_0[1]/data GND GND nfet w=5 l=2
+  ad=30 pd=22 as=0 ps=0
M2391 datapath_0/register_1/register_one_0[1]/inv_0/in datapath_0/register_1/register_one_0[1]/data Vdd Vdd pfet w=10 l=2
+  ad=60 pd=32 as=0 ps=0
M2392 datapath_0/register_1/register_one_0[1]/notw fsm_0/reg1w GND GND nfet w=5 l=2
+  ad=30 pd=22 as=0 ps=0
M2393 datapath_0/register_1/register_one_0[1]/notw fsm_0/reg1w Vdd Vdd pfet w=10 l=2
+  ad=60 pd=32 as=0 ps=0
M2394 GND datapath_0/register_1/register_one_0[1]/notw datapath_0/register_1/register_one_0[1]/new_latch_0/a_82_52# GND nfet w=5 l=2
+  ad=0 pd=0 as=30 ps=22
M2395 datapath_0/register_1/register_one_0[1]/new_latch_0/a_99_34# datapath_0/register_1/register_one_0[1]/new_latch_0/a_79_32# Vdd Vdd pfet w=10 l=2
+  ad=40 pd=28 as=0 ps=0
M2396 datapath_0/register_1/register_one_0[1]/new_latch_0/a_79_32# datapath_0/register_1/register_one_0[1]/data Vdd Vdd pfet w=10 l=2
+  ad=60 pd=32 as=0 ps=0
M2397 datapath_0/register_1/register_one_0[1]/tp1 datapath_0/register_1/register_one_0[1]/new_latch_0/a_82_52# datapath_0/register_1/register_one_0[1]/new_latch_0/a_99_34# Vdd pfet w=10 l=2
+  ad=0 pd=0 as=0 ps=0
M2398 datapath_0/register_1/register_one_0[1]/new_latch_0/a_82_34# datapath_0/register_1/register_one_0[1]/new_latch_0/a_79_32# GND GND nfet w=5 l=2
+  ad=20 pd=18 as=0 ps=0
M2399 datapath_0/register_1/register_one_0[1]/new_latch_0/a_79_32# datapath_0/register_1/register_one_0[1]/data GND GND nfet w=5 l=2
+  ad=30 pd=22 as=0 ps=0
M2400 datapath_0/register_1/register_one_0[1]/tp1 datapath_0/register_1/register_one_0[1]/notw datapath_0/register_1/register_one_0[1]/new_latch_0/a_82_34# GND nfet w=5 l=2
+  ad=0 pd=0 as=0 ps=0
M2401 Vdd datapath_0/register_1/register_one_0[1]/notw datapath_0/register_1/register_one_0[1]/new_latch_0/a_82_52# Vdd pfet w=10 l=2
+  ad=0 pd=0 as=60 ps=32
M2402 GND fsm_0/reg1w datapath_0/register_1/register_one_0[1]/new_latch_1/a_82_52# GND nfet w=5 l=2
+  ad=0 pd=0 as=30 ps=22
M2403 datapath_0/register_1/register_one_0[1]/new_latch_1/a_99_34# datapath_0/register_1/register_one_0[1]/new_latch_1/a_79_32# Vdd Vdd pfet w=10 l=2
+  ad=40 pd=28 as=0 ps=0
M2404 datapath_0/register_1/register_one_0[1]/new_latch_1/a_79_32# datapath_0/wz1 Vdd Vdd pfet w=10 l=2
+  ad=60 pd=32 as=0 ps=0
M2405 datapath_0/register_1/register_one_0[1]/data datapath_0/register_1/register_one_0[1]/new_latch_1/a_82_52# datapath_0/register_1/register_one_0[1]/new_latch_1/a_99_34# Vdd pfet w=10 l=2
+  ad=60 pd=32 as=0 ps=0
M2406 datapath_0/register_1/register_one_0[1]/new_latch_1/a_82_34# datapath_0/register_1/register_one_0[1]/new_latch_1/a_79_32# GND GND nfet w=5 l=2
+  ad=20 pd=18 as=0 ps=0
M2407 datapath_0/register_1/register_one_0[1]/new_latch_1/a_79_32# datapath_0/wz1 GND GND nfet w=5 l=2
+  ad=30 pd=22 as=0 ps=0
M2408 datapath_0/register_1/register_one_0[1]/data fsm_0/reg1w datapath_0/register_1/register_one_0[1]/new_latch_1/a_82_34# GND nfet w=5 l=2
+  ad=30 pd=22 as=0 ps=0
M2409 Vdd fsm_0/reg1w datapath_0/register_1/register_one_0[1]/new_latch_1/a_82_52# Vdd pfet w=10 l=2
+  ad=0 pd=0 as=60 ps=32
M2410 GND datapath_0/reg2r1 datapath_0/register_1/register_one_0[1]/new_latch_2/a_82_52# GND nfet w=5 l=2
+  ad=0 pd=0 as=30 ps=22
M2411 datapath_0/register_1/register_one_0[1]/new_latch_2/a_99_34# datapath_0/register_1/register_one_0[1]/new_latch_2/a_79_32# Vdd Vdd pfet w=10 l=2
+  ad=40 pd=28 as=0 ps=0
M2412 datapath_0/register_1/register_one_0[1]/new_latch_2/a_79_32# datapath_0/register_1/register_one_0[1]/data Vdd Vdd pfet w=10 l=2
+  ad=60 pd=32 as=0 ps=0
M2413 datapath_0/rx1 datapath_0/register_1/register_one_0[1]/new_latch_2/a_82_52# datapath_0/register_1/register_one_0[1]/new_latch_2/a_99_34# Vdd pfet w=10 l=2
+  ad=0 pd=0 as=0 ps=0
M2414 datapath_0/register_1/register_one_0[1]/new_latch_2/a_82_34# datapath_0/register_1/register_one_0[1]/new_latch_2/a_79_32# GND GND nfet w=5 l=2
+  ad=20 pd=18 as=0 ps=0
M2415 datapath_0/register_1/register_one_0[1]/new_latch_2/a_79_32# datapath_0/register_1/register_one_0[1]/data GND GND nfet w=5 l=2
+  ad=30 pd=22 as=0 ps=0
M2416 datapath_0/rx1 datapath_0/reg2r1 datapath_0/register_1/register_one_0[1]/new_latch_2/a_82_34# GND nfet w=5 l=2
+  ad=0 pd=0 as=0 ps=0
M2417 Vdd datapath_0/reg2r1 datapath_0/register_1/register_one_0[1]/new_latch_2/a_82_52# Vdd pfet w=10 l=2
+  ad=0 pd=0 as=60 ps=32
M2418 GND fsm_0/reg1r1 datapath_0/register_1/register_one_0[1]/new_latch_3/a_82_52# GND nfet w=5 l=2
+  ad=0 pd=0 as=30 ps=22
M2419 datapath_0/register_1/register_one_0[1]/new_latch_3/a_99_34# datapath_0/register_1/register_one_0[1]/new_latch_3/a_79_32# Vdd Vdd pfet w=10 l=2
+  ad=40 pd=28 as=0 ps=0
M2420 datapath_0/register_1/register_one_0[1]/new_latch_3/a_79_32# datapath_0/register_1/register_one_0[1]/data Vdd Vdd pfet w=10 l=2
+  ad=60 pd=32 as=0 ps=0
M2421 datapath_0/ry1 datapath_0/register_1/register_one_0[1]/new_latch_3/a_82_52# datapath_0/register_1/register_one_0[1]/new_latch_3/a_99_34# Vdd pfet w=10 l=2
+  ad=0 pd=0 as=0 ps=0
M2422 datapath_0/register_1/register_one_0[1]/new_latch_3/a_82_34# datapath_0/register_1/register_one_0[1]/new_latch_3/a_79_32# GND GND nfet w=5 l=2
+  ad=20 pd=18 as=0 ps=0
M2423 datapath_0/register_1/register_one_0[1]/new_latch_3/a_79_32# datapath_0/register_1/register_one_0[1]/data GND GND nfet w=5 l=2
+  ad=30 pd=22 as=0 ps=0
M2424 datapath_0/ry1 fsm_0/reg1r1 datapath_0/register_1/register_one_0[1]/new_latch_3/a_82_34# GND nfet w=5 l=2
+  ad=0 pd=0 as=0 ps=0
M2425 Vdd fsm_0/reg1r1 datapath_0/register_1/register_one_0[1]/new_latch_3/a_82_52# Vdd pfet w=10 l=2
+  ad=0 pd=0 as=60 ps=32
M2426 datapath_0/register_1/register_one_0[2]/tp1 datapath_0/register_1/register_one_0[2]/inv_0/in GND GND nfet w=5 l=2
+  ad=60 pd=44 as=0 ps=0
M2427 datapath_0/register_1/register_one_0[2]/tp1 datapath_0/register_1/register_one_0[2]/inv_0/in Vdd Vdd pfet w=10 l=2
+  ad=120 pd=64 as=0 ps=0
M2428 datapath_0/register_1/register_one_0[2]/inv_0/in datapath_0/register_1/register_one_0[2]/data GND GND nfet w=5 l=2
+  ad=30 pd=22 as=0 ps=0
M2429 datapath_0/register_1/register_one_0[2]/inv_0/in datapath_0/register_1/register_one_0[2]/data Vdd Vdd pfet w=10 l=2
+  ad=60 pd=32 as=0 ps=0
M2430 datapath_0/register_1/register_one_0[2]/notw fsm_0/reg1w GND GND nfet w=5 l=2
+  ad=30 pd=22 as=0 ps=0
M2431 datapath_0/register_1/register_one_0[2]/notw fsm_0/reg1w Vdd Vdd pfet w=10 l=2
+  ad=60 pd=32 as=0 ps=0
M2432 GND datapath_0/register_1/register_one_0[2]/notw datapath_0/register_1/register_one_0[2]/new_latch_0/a_82_52# GND nfet w=5 l=2
+  ad=0 pd=0 as=30 ps=22
M2433 datapath_0/register_1/register_one_0[2]/new_latch_0/a_99_34# datapath_0/register_1/register_one_0[2]/new_latch_0/a_79_32# Vdd Vdd pfet w=10 l=2
+  ad=40 pd=28 as=0 ps=0
M2434 datapath_0/register_1/register_one_0[2]/new_latch_0/a_79_32# datapath_0/register_1/register_one_0[2]/data Vdd Vdd pfet w=10 l=2
+  ad=60 pd=32 as=0 ps=0
M2435 datapath_0/register_1/register_one_0[2]/tp1 datapath_0/register_1/register_one_0[2]/new_latch_0/a_82_52# datapath_0/register_1/register_one_0[2]/new_latch_0/a_99_34# Vdd pfet w=10 l=2
+  ad=0 pd=0 as=0 ps=0
M2436 datapath_0/register_1/register_one_0[2]/new_latch_0/a_82_34# datapath_0/register_1/register_one_0[2]/new_latch_0/a_79_32# GND GND nfet w=5 l=2
+  ad=20 pd=18 as=0 ps=0
M2437 datapath_0/register_1/register_one_0[2]/new_latch_0/a_79_32# datapath_0/register_1/register_one_0[2]/data GND GND nfet w=5 l=2
+  ad=30 pd=22 as=0 ps=0
M2438 datapath_0/register_1/register_one_0[2]/tp1 datapath_0/register_1/register_one_0[2]/notw datapath_0/register_1/register_one_0[2]/new_latch_0/a_82_34# GND nfet w=5 l=2
+  ad=0 pd=0 as=0 ps=0
M2439 Vdd datapath_0/register_1/register_one_0[2]/notw datapath_0/register_1/register_one_0[2]/new_latch_0/a_82_52# Vdd pfet w=10 l=2
+  ad=0 pd=0 as=60 ps=32
M2440 GND fsm_0/reg1w datapath_0/register_1/register_one_0[2]/new_latch_1/a_82_52# GND nfet w=5 l=2
+  ad=0 pd=0 as=30 ps=22
M2441 datapath_0/register_1/register_one_0[2]/new_latch_1/a_99_34# datapath_0/register_1/register_one_0[2]/new_latch_1/a_79_32# Vdd Vdd pfet w=10 l=2
+  ad=40 pd=28 as=0 ps=0
M2442 datapath_0/register_1/register_one_0[2]/new_latch_1/a_79_32# datapath_0/wz2 Vdd Vdd pfet w=10 l=2
+  ad=60 pd=32 as=0 ps=0
M2443 datapath_0/register_1/register_one_0[2]/data datapath_0/register_1/register_one_0[2]/new_latch_1/a_82_52# datapath_0/register_1/register_one_0[2]/new_latch_1/a_99_34# Vdd pfet w=10 l=2
+  ad=60 pd=32 as=0 ps=0
M2444 datapath_0/register_1/register_one_0[2]/new_latch_1/a_82_34# datapath_0/register_1/register_one_0[2]/new_latch_1/a_79_32# GND GND nfet w=5 l=2
+  ad=20 pd=18 as=0 ps=0
M2445 datapath_0/register_1/register_one_0[2]/new_latch_1/a_79_32# datapath_0/wz2 GND GND nfet w=5 l=2
+  ad=30 pd=22 as=0 ps=0
M2446 datapath_0/register_1/register_one_0[2]/data fsm_0/reg1w datapath_0/register_1/register_one_0[2]/new_latch_1/a_82_34# GND nfet w=5 l=2
+  ad=30 pd=22 as=0 ps=0
M2447 Vdd fsm_0/reg1w datapath_0/register_1/register_one_0[2]/new_latch_1/a_82_52# Vdd pfet w=10 l=2
+  ad=0 pd=0 as=60 ps=32
M2448 GND datapath_0/reg2r1 datapath_0/register_1/register_one_0[2]/new_latch_2/a_82_52# GND nfet w=5 l=2
+  ad=0 pd=0 as=30 ps=22
M2449 datapath_0/register_1/register_one_0[2]/new_latch_2/a_99_34# datapath_0/register_1/register_one_0[2]/new_latch_2/a_79_32# Vdd Vdd pfet w=10 l=2
+  ad=40 pd=28 as=0 ps=0
M2450 datapath_0/register_1/register_one_0[2]/new_latch_2/a_79_32# datapath_0/register_1/register_one_0[2]/data Vdd Vdd pfet w=10 l=2
+  ad=60 pd=32 as=0 ps=0
M2451 datapath_0/rx2 datapath_0/register_1/register_one_0[2]/new_latch_2/a_82_52# datapath_0/register_1/register_one_0[2]/new_latch_2/a_99_34# Vdd pfet w=10 l=2
+  ad=0 pd=0 as=0 ps=0
M2452 datapath_0/register_1/register_one_0[2]/new_latch_2/a_82_34# datapath_0/register_1/register_one_0[2]/new_latch_2/a_79_32# GND GND nfet w=5 l=2
+  ad=20 pd=18 as=0 ps=0
M2453 datapath_0/register_1/register_one_0[2]/new_latch_2/a_79_32# datapath_0/register_1/register_one_0[2]/data GND GND nfet w=5 l=2
+  ad=30 pd=22 as=0 ps=0
M2454 datapath_0/rx2 datapath_0/reg2r1 datapath_0/register_1/register_one_0[2]/new_latch_2/a_82_34# GND nfet w=5 l=2
+  ad=0 pd=0 as=0 ps=0
M2455 Vdd datapath_0/reg2r1 datapath_0/register_1/register_one_0[2]/new_latch_2/a_82_52# Vdd pfet w=10 l=2
+  ad=0 pd=0 as=60 ps=32
M2456 GND fsm_0/reg1r1 datapath_0/register_1/register_one_0[2]/new_latch_3/a_82_52# GND nfet w=5 l=2
+  ad=0 pd=0 as=30 ps=22
M2457 datapath_0/register_1/register_one_0[2]/new_latch_3/a_99_34# datapath_0/register_1/register_one_0[2]/new_latch_3/a_79_32# Vdd Vdd pfet w=10 l=2
+  ad=40 pd=28 as=0 ps=0
M2458 datapath_0/register_1/register_one_0[2]/new_latch_3/a_79_32# datapath_0/register_1/register_one_0[2]/data Vdd Vdd pfet w=10 l=2
+  ad=60 pd=32 as=0 ps=0
M2459 datapath_0/ry2 datapath_0/register_1/register_one_0[2]/new_latch_3/a_82_52# datapath_0/register_1/register_one_0[2]/new_latch_3/a_99_34# Vdd pfet w=10 l=2
+  ad=0 pd=0 as=0 ps=0
M2460 datapath_0/register_1/register_one_0[2]/new_latch_3/a_82_34# datapath_0/register_1/register_one_0[2]/new_latch_3/a_79_32# GND GND nfet w=5 l=2
+  ad=20 pd=18 as=0 ps=0
M2461 datapath_0/register_1/register_one_0[2]/new_latch_3/a_79_32# datapath_0/register_1/register_one_0[2]/data GND GND nfet w=5 l=2
+  ad=30 pd=22 as=0 ps=0
M2462 datapath_0/ry2 fsm_0/reg1r1 datapath_0/register_1/register_one_0[2]/new_latch_3/a_82_34# GND nfet w=5 l=2
+  ad=0 pd=0 as=0 ps=0
M2463 Vdd fsm_0/reg1r1 datapath_0/register_1/register_one_0[2]/new_latch_3/a_82_52# Vdd pfet w=10 l=2
+  ad=0 pd=0 as=60 ps=32
M2464 datapath_0/register_1/register_one_0[3]/tp1 datapath_0/register_1/register_one_0[3]/inv_0/in GND GND nfet w=5 l=2
+  ad=60 pd=44 as=0 ps=0
M2465 datapath_0/register_1/register_one_0[3]/tp1 datapath_0/register_1/register_one_0[3]/inv_0/in Vdd Vdd pfet w=10 l=2
+  ad=120 pd=64 as=0 ps=0
M2466 datapath_0/register_1/register_one_0[3]/inv_0/in datapath_0/register_1/register_one_0[3]/data GND GND nfet w=5 l=2
+  ad=30 pd=22 as=0 ps=0
M2467 datapath_0/register_1/register_one_0[3]/inv_0/in datapath_0/register_1/register_one_0[3]/data Vdd Vdd pfet w=10 l=2
+  ad=60 pd=32 as=0 ps=0
M2468 datapath_0/register_1/register_one_0[3]/notw fsm_0/reg1w GND GND nfet w=5 l=2
+  ad=30 pd=22 as=0 ps=0
M2469 datapath_0/register_1/register_one_0[3]/notw fsm_0/reg1w Vdd Vdd pfet w=10 l=2
+  ad=60 pd=32 as=0 ps=0
M2470 GND datapath_0/register_1/register_one_0[3]/notw datapath_0/register_1/register_one_0[3]/new_latch_0/a_82_52# GND nfet w=5 l=2
+  ad=0 pd=0 as=30 ps=22
M2471 datapath_0/register_1/register_one_0[3]/new_latch_0/a_99_34# datapath_0/register_1/register_one_0[3]/new_latch_0/a_79_32# Vdd Vdd pfet w=10 l=2
+  ad=40 pd=28 as=0 ps=0
M2472 datapath_0/register_1/register_one_0[3]/new_latch_0/a_79_32# datapath_0/register_1/register_one_0[3]/data Vdd Vdd pfet w=10 l=2
+  ad=60 pd=32 as=0 ps=0
M2473 datapath_0/register_1/register_one_0[3]/tp1 datapath_0/register_1/register_one_0[3]/new_latch_0/a_82_52# datapath_0/register_1/register_one_0[3]/new_latch_0/a_99_34# Vdd pfet w=10 l=2
+  ad=0 pd=0 as=0 ps=0
M2474 datapath_0/register_1/register_one_0[3]/new_latch_0/a_82_34# datapath_0/register_1/register_one_0[3]/new_latch_0/a_79_32# GND GND nfet w=5 l=2
+  ad=20 pd=18 as=0 ps=0
M2475 datapath_0/register_1/register_one_0[3]/new_latch_0/a_79_32# datapath_0/register_1/register_one_0[3]/data GND GND nfet w=5 l=2
+  ad=30 pd=22 as=0 ps=0
M2476 datapath_0/register_1/register_one_0[3]/tp1 datapath_0/register_1/register_one_0[3]/notw datapath_0/register_1/register_one_0[3]/new_latch_0/a_82_34# GND nfet w=5 l=2
+  ad=0 pd=0 as=0 ps=0
M2477 Vdd datapath_0/register_1/register_one_0[3]/notw datapath_0/register_1/register_one_0[3]/new_latch_0/a_82_52# Vdd pfet w=10 l=2
+  ad=0 pd=0 as=60 ps=32
M2478 GND fsm_0/reg1w datapath_0/register_1/register_one_0[3]/new_latch_1/a_82_52# GND nfet w=5 l=2
+  ad=0 pd=0 as=30 ps=22
M2479 datapath_0/register_1/register_one_0[3]/new_latch_1/a_99_34# datapath_0/register_1/register_one_0[3]/new_latch_1/a_79_32# Vdd Vdd pfet w=10 l=2
+  ad=40 pd=28 as=0 ps=0
M2480 datapath_0/register_1/register_one_0[3]/new_latch_1/a_79_32# datapath_0/wz3 Vdd Vdd pfet w=10 l=2
+  ad=60 pd=32 as=0 ps=0
M2481 datapath_0/register_1/register_one_0[3]/data datapath_0/register_1/register_one_0[3]/new_latch_1/a_82_52# datapath_0/register_1/register_one_0[3]/new_latch_1/a_99_34# Vdd pfet w=10 l=2
+  ad=60 pd=32 as=0 ps=0
M2482 datapath_0/register_1/register_one_0[3]/new_latch_1/a_82_34# datapath_0/register_1/register_one_0[3]/new_latch_1/a_79_32# GND GND nfet w=5 l=2
+  ad=20 pd=18 as=0 ps=0
M2483 datapath_0/register_1/register_one_0[3]/new_latch_1/a_79_32# datapath_0/wz3 GND GND nfet w=5 l=2
+  ad=30 pd=22 as=0 ps=0
M2484 datapath_0/register_1/register_one_0[3]/data fsm_0/reg1w datapath_0/register_1/register_one_0[3]/new_latch_1/a_82_34# GND nfet w=5 l=2
+  ad=30 pd=22 as=0 ps=0
M2485 Vdd fsm_0/reg1w datapath_0/register_1/register_one_0[3]/new_latch_1/a_82_52# Vdd pfet w=10 l=2
+  ad=0 pd=0 as=60 ps=32
M2486 GND datapath_0/reg2r1 datapath_0/register_1/register_one_0[3]/new_latch_2/a_82_52# GND nfet w=5 l=2
+  ad=0 pd=0 as=30 ps=22
M2487 datapath_0/register_1/register_one_0[3]/new_latch_2/a_99_34# datapath_0/register_1/register_one_0[3]/new_latch_2/a_79_32# Vdd Vdd pfet w=10 l=2
+  ad=40 pd=28 as=0 ps=0
M2488 datapath_0/register_1/register_one_0[3]/new_latch_2/a_79_32# datapath_0/register_1/register_one_0[3]/data Vdd Vdd pfet w=10 l=2
+  ad=60 pd=32 as=0 ps=0
M2489 datapath_0/rx3 datapath_0/register_1/register_one_0[3]/new_latch_2/a_82_52# datapath_0/register_1/register_one_0[3]/new_latch_2/a_99_34# Vdd pfet w=10 l=2
+  ad=0 pd=0 as=0 ps=0
M2490 datapath_0/register_1/register_one_0[3]/new_latch_2/a_82_34# datapath_0/register_1/register_one_0[3]/new_latch_2/a_79_32# GND GND nfet w=5 l=2
+  ad=20 pd=18 as=0 ps=0
M2491 datapath_0/register_1/register_one_0[3]/new_latch_2/a_79_32# datapath_0/register_1/register_one_0[3]/data GND GND nfet w=5 l=2
+  ad=30 pd=22 as=0 ps=0
M2492 datapath_0/rx3 datapath_0/reg2r1 datapath_0/register_1/register_one_0[3]/new_latch_2/a_82_34# GND nfet w=5 l=2
+  ad=0 pd=0 as=0 ps=0
M2493 Vdd datapath_0/reg2r1 datapath_0/register_1/register_one_0[3]/new_latch_2/a_82_52# Vdd pfet w=10 l=2
+  ad=0 pd=0 as=60 ps=32
M2494 GND fsm_0/reg1r1 datapath_0/register_1/register_one_0[3]/new_latch_3/a_82_52# GND nfet w=5 l=2
+  ad=0 pd=0 as=30 ps=22
M2495 datapath_0/register_1/register_one_0[3]/new_latch_3/a_99_34# datapath_0/register_1/register_one_0[3]/new_latch_3/a_79_32# Vdd Vdd pfet w=10 l=2
+  ad=40 pd=28 as=0 ps=0
M2496 datapath_0/register_1/register_one_0[3]/new_latch_3/a_79_32# datapath_0/register_1/register_one_0[3]/data Vdd Vdd pfet w=10 l=2
+  ad=60 pd=32 as=0 ps=0
M2497 datapath_0/ry3 datapath_0/register_1/register_one_0[3]/new_latch_3/a_82_52# datapath_0/register_1/register_one_0[3]/new_latch_3/a_99_34# Vdd pfet w=10 l=2
+  ad=0 pd=0 as=0 ps=0
M2498 datapath_0/register_1/register_one_0[3]/new_latch_3/a_82_34# datapath_0/register_1/register_one_0[3]/new_latch_3/a_79_32# GND GND nfet w=5 l=2
+  ad=20 pd=18 as=0 ps=0
M2499 datapath_0/register_1/register_one_0[3]/new_latch_3/a_79_32# datapath_0/register_1/register_one_0[3]/data GND GND nfet w=5 l=2
+  ad=30 pd=22 as=0 ps=0
M2500 datapath_0/ry3 fsm_0/reg1r1 datapath_0/register_1/register_one_0[3]/new_latch_3/a_82_34# GND nfet w=5 l=2
+  ad=0 pd=0 as=0 ps=0
M2501 Vdd fsm_0/reg1r1 datapath_0/register_1/register_one_0[3]/new_latch_3/a_82_52# Vdd pfet w=10 l=2
+  ad=0 pd=0 as=60 ps=32
M2502 datapath_0/register_1/register_one_0[4]/tp1 datapath_0/register_1/register_one_0[4]/inv_0/in GND GND nfet w=5 l=2
+  ad=60 pd=44 as=0 ps=0
M2503 datapath_0/register_1/register_one_0[4]/tp1 datapath_0/register_1/register_one_0[4]/inv_0/in Vdd Vdd pfet w=10 l=2
+  ad=120 pd=64 as=0 ps=0
M2504 datapath_0/register_1/register_one_0[4]/inv_0/in datapath_0/register_1/register_one_0[4]/data GND GND nfet w=5 l=2
+  ad=30 pd=22 as=0 ps=0
M2505 datapath_0/register_1/register_one_0[4]/inv_0/in datapath_0/register_1/register_one_0[4]/data Vdd Vdd pfet w=10 l=2
+  ad=60 pd=32 as=0 ps=0
M2506 datapath_0/register_1/register_one_0[4]/notw fsm_0/reg1w GND GND nfet w=5 l=2
+  ad=30 pd=22 as=0 ps=0
M2507 datapath_0/register_1/register_one_0[4]/notw fsm_0/reg1w Vdd Vdd pfet w=10 l=2
+  ad=60 pd=32 as=0 ps=0
M2508 GND datapath_0/register_1/register_one_0[4]/notw datapath_0/register_1/register_one_0[4]/new_latch_0/a_82_52# GND nfet w=5 l=2
+  ad=0 pd=0 as=30 ps=22
M2509 datapath_0/register_1/register_one_0[4]/new_latch_0/a_99_34# datapath_0/register_1/register_one_0[4]/new_latch_0/a_79_32# Vdd Vdd pfet w=10 l=2
+  ad=40 pd=28 as=0 ps=0
M2510 datapath_0/register_1/register_one_0[4]/new_latch_0/a_79_32# datapath_0/register_1/register_one_0[4]/data Vdd Vdd pfet w=10 l=2
+  ad=60 pd=32 as=0 ps=0
M2511 datapath_0/register_1/register_one_0[4]/tp1 datapath_0/register_1/register_one_0[4]/new_latch_0/a_82_52# datapath_0/register_1/register_one_0[4]/new_latch_0/a_99_34# Vdd pfet w=10 l=2
+  ad=0 pd=0 as=0 ps=0
M2512 datapath_0/register_1/register_one_0[4]/new_latch_0/a_82_34# datapath_0/register_1/register_one_0[4]/new_latch_0/a_79_32# GND GND nfet w=5 l=2
+  ad=20 pd=18 as=0 ps=0
M2513 datapath_0/register_1/register_one_0[4]/new_latch_0/a_79_32# datapath_0/register_1/register_one_0[4]/data GND GND nfet w=5 l=2
+  ad=30 pd=22 as=0 ps=0
M2514 datapath_0/register_1/register_one_0[4]/tp1 datapath_0/register_1/register_one_0[4]/notw datapath_0/register_1/register_one_0[4]/new_latch_0/a_82_34# GND nfet w=5 l=2
+  ad=0 pd=0 as=0 ps=0
M2515 Vdd datapath_0/register_1/register_one_0[4]/notw datapath_0/register_1/register_one_0[4]/new_latch_0/a_82_52# Vdd pfet w=10 l=2
+  ad=0 pd=0 as=60 ps=32
M2516 GND fsm_0/reg1w datapath_0/register_1/register_one_0[4]/new_latch_1/a_82_52# GND nfet w=5 l=2
+  ad=0 pd=0 as=30 ps=22
M2517 datapath_0/register_1/register_one_0[4]/new_latch_1/a_99_34# datapath_0/register_1/register_one_0[4]/new_latch_1/a_79_32# Vdd Vdd pfet w=10 l=2
+  ad=40 pd=28 as=0 ps=0
M2518 datapath_0/register_1/register_one_0[4]/new_latch_1/a_79_32# datapath_0/wz4 Vdd Vdd pfet w=10 l=2
+  ad=60 pd=32 as=0 ps=0
M2519 datapath_0/register_1/register_one_0[4]/data datapath_0/register_1/register_one_0[4]/new_latch_1/a_82_52# datapath_0/register_1/register_one_0[4]/new_latch_1/a_99_34# Vdd pfet w=10 l=2
+  ad=60 pd=32 as=0 ps=0
M2520 datapath_0/register_1/register_one_0[4]/new_latch_1/a_82_34# datapath_0/register_1/register_one_0[4]/new_latch_1/a_79_32# GND GND nfet w=5 l=2
+  ad=20 pd=18 as=0 ps=0
M2521 datapath_0/register_1/register_one_0[4]/new_latch_1/a_79_32# datapath_0/wz4 GND GND nfet w=5 l=2
+  ad=30 pd=22 as=0 ps=0
M2522 datapath_0/register_1/register_one_0[4]/data fsm_0/reg1w datapath_0/register_1/register_one_0[4]/new_latch_1/a_82_34# GND nfet w=5 l=2
+  ad=30 pd=22 as=0 ps=0
M2523 Vdd fsm_0/reg1w datapath_0/register_1/register_one_0[4]/new_latch_1/a_82_52# Vdd pfet w=10 l=2
+  ad=0 pd=0 as=60 ps=32
M2524 GND datapath_0/reg2r1 datapath_0/register_1/register_one_0[4]/new_latch_2/a_82_52# GND nfet w=5 l=2
+  ad=0 pd=0 as=30 ps=22
M2525 datapath_0/register_1/register_one_0[4]/new_latch_2/a_99_34# datapath_0/register_1/register_one_0[4]/new_latch_2/a_79_32# Vdd Vdd pfet w=10 l=2
+  ad=40 pd=28 as=0 ps=0
M2526 datapath_0/register_1/register_one_0[4]/new_latch_2/a_79_32# datapath_0/register_1/register_one_0[4]/data Vdd Vdd pfet w=10 l=2
+  ad=60 pd=32 as=0 ps=0
M2527 datapath_0/rx4 datapath_0/register_1/register_one_0[4]/new_latch_2/a_82_52# datapath_0/register_1/register_one_0[4]/new_latch_2/a_99_34# Vdd pfet w=10 l=2
+  ad=0 pd=0 as=0 ps=0
M2528 datapath_0/register_1/register_one_0[4]/new_latch_2/a_82_34# datapath_0/register_1/register_one_0[4]/new_latch_2/a_79_32# GND GND nfet w=5 l=2
+  ad=20 pd=18 as=0 ps=0
M2529 datapath_0/register_1/register_one_0[4]/new_latch_2/a_79_32# datapath_0/register_1/register_one_0[4]/data GND GND nfet w=5 l=2
+  ad=30 pd=22 as=0 ps=0
M2530 datapath_0/rx4 datapath_0/reg2r1 datapath_0/register_1/register_one_0[4]/new_latch_2/a_82_34# GND nfet w=5 l=2
+  ad=0 pd=0 as=0 ps=0
M2531 Vdd datapath_0/reg2r1 datapath_0/register_1/register_one_0[4]/new_latch_2/a_82_52# Vdd pfet w=10 l=2
+  ad=0 pd=0 as=60 ps=32
M2532 GND fsm_0/reg1r1 datapath_0/register_1/register_one_0[4]/new_latch_3/a_82_52# GND nfet w=5 l=2
+  ad=0 pd=0 as=30 ps=22
M2533 datapath_0/register_1/register_one_0[4]/new_latch_3/a_99_34# datapath_0/register_1/register_one_0[4]/new_latch_3/a_79_32# Vdd Vdd pfet w=10 l=2
+  ad=40 pd=28 as=0 ps=0
M2534 datapath_0/register_1/register_one_0[4]/new_latch_3/a_79_32# datapath_0/register_1/register_one_0[4]/data Vdd Vdd pfet w=10 l=2
+  ad=60 pd=32 as=0 ps=0
M2535 datapath_0/ry4 datapath_0/register_1/register_one_0[4]/new_latch_3/a_82_52# datapath_0/register_1/register_one_0[4]/new_latch_3/a_99_34# Vdd pfet w=10 l=2
+  ad=0 pd=0 as=0 ps=0
M2536 datapath_0/register_1/register_one_0[4]/new_latch_3/a_82_34# datapath_0/register_1/register_one_0[4]/new_latch_3/a_79_32# GND GND nfet w=5 l=2
+  ad=20 pd=18 as=0 ps=0
M2537 datapath_0/register_1/register_one_0[4]/new_latch_3/a_79_32# datapath_0/register_1/register_one_0[4]/data GND GND nfet w=5 l=2
+  ad=30 pd=22 as=0 ps=0
M2538 datapath_0/ry4 fsm_0/reg1r1 datapath_0/register_1/register_one_0[4]/new_latch_3/a_82_34# GND nfet w=5 l=2
+  ad=0 pd=0 as=0 ps=0
M2539 Vdd fsm_0/reg1r1 datapath_0/register_1/register_one_0[4]/new_latch_3/a_82_52# Vdd pfet w=10 l=2
+  ad=0 pd=0 as=60 ps=32
M2540 datapath_0/register_1/register_one_0[5]/tp1 datapath_0/register_1/register_one_0[5]/inv_0/in GND GND nfet w=5 l=2
+  ad=60 pd=44 as=0 ps=0
M2541 datapath_0/register_1/register_one_0[5]/tp1 datapath_0/register_1/register_one_0[5]/inv_0/in Vdd Vdd pfet w=10 l=2
+  ad=120 pd=64 as=0 ps=0
M2542 datapath_0/register_1/register_one_0[5]/inv_0/in datapath_0/register_1/register_one_0[5]/data GND GND nfet w=5 l=2
+  ad=30 pd=22 as=0 ps=0
M2543 datapath_0/register_1/register_one_0[5]/inv_0/in datapath_0/register_1/register_one_0[5]/data Vdd Vdd pfet w=10 l=2
+  ad=60 pd=32 as=0 ps=0
M2544 datapath_0/register_1/register_one_0[5]/notw fsm_0/reg1w GND GND nfet w=5 l=2
+  ad=30 pd=22 as=0 ps=0
M2545 datapath_0/register_1/register_one_0[5]/notw fsm_0/reg1w Vdd Vdd pfet w=10 l=2
+  ad=60 pd=32 as=0 ps=0
M2546 GND datapath_0/register_1/register_one_0[5]/notw datapath_0/register_1/register_one_0[5]/new_latch_0/a_82_52# GND nfet w=5 l=2
+  ad=0 pd=0 as=30 ps=22
M2547 datapath_0/register_1/register_one_0[5]/new_latch_0/a_99_34# datapath_0/register_1/register_one_0[5]/new_latch_0/a_79_32# Vdd Vdd pfet w=10 l=2
+  ad=40 pd=28 as=0 ps=0
M2548 datapath_0/register_1/register_one_0[5]/new_latch_0/a_79_32# datapath_0/register_1/register_one_0[5]/data Vdd Vdd pfet w=10 l=2
+  ad=60 pd=32 as=0 ps=0
M2549 datapath_0/register_1/register_one_0[5]/tp1 datapath_0/register_1/register_one_0[5]/new_latch_0/a_82_52# datapath_0/register_1/register_one_0[5]/new_latch_0/a_99_34# Vdd pfet w=10 l=2
+  ad=0 pd=0 as=0 ps=0
M2550 datapath_0/register_1/register_one_0[5]/new_latch_0/a_82_34# datapath_0/register_1/register_one_0[5]/new_latch_0/a_79_32# GND GND nfet w=5 l=2
+  ad=20 pd=18 as=0 ps=0
M2551 datapath_0/register_1/register_one_0[5]/new_latch_0/a_79_32# datapath_0/register_1/register_one_0[5]/data GND GND nfet w=5 l=2
+  ad=30 pd=22 as=0 ps=0
M2552 datapath_0/register_1/register_one_0[5]/tp1 datapath_0/register_1/register_one_0[5]/notw datapath_0/register_1/register_one_0[5]/new_latch_0/a_82_34# GND nfet w=5 l=2
+  ad=0 pd=0 as=0 ps=0
M2553 Vdd datapath_0/register_1/register_one_0[5]/notw datapath_0/register_1/register_one_0[5]/new_latch_0/a_82_52# Vdd pfet w=10 l=2
+  ad=0 pd=0 as=60 ps=32
M2554 GND fsm_0/reg1w datapath_0/register_1/register_one_0[5]/new_latch_1/a_82_52# GND nfet w=5 l=2
+  ad=0 pd=0 as=30 ps=22
M2555 datapath_0/register_1/register_one_0[5]/new_latch_1/a_99_34# datapath_0/register_1/register_one_0[5]/new_latch_1/a_79_32# Vdd Vdd pfet w=10 l=2
+  ad=40 pd=28 as=0 ps=0
M2556 datapath_0/register_1/register_one_0[5]/new_latch_1/a_79_32# datapath_0/wz5 Vdd Vdd pfet w=10 l=2
+  ad=60 pd=32 as=0 ps=0
M2557 datapath_0/register_1/register_one_0[5]/data datapath_0/register_1/register_one_0[5]/new_latch_1/a_82_52# datapath_0/register_1/register_one_0[5]/new_latch_1/a_99_34# Vdd pfet w=10 l=2
+  ad=60 pd=32 as=0 ps=0
M2558 datapath_0/register_1/register_one_0[5]/new_latch_1/a_82_34# datapath_0/register_1/register_one_0[5]/new_latch_1/a_79_32# GND GND nfet w=5 l=2
+  ad=20 pd=18 as=0 ps=0
M2559 datapath_0/register_1/register_one_0[5]/new_latch_1/a_79_32# datapath_0/wz5 GND GND nfet w=5 l=2
+  ad=30 pd=22 as=0 ps=0
M2560 datapath_0/register_1/register_one_0[5]/data fsm_0/reg1w datapath_0/register_1/register_one_0[5]/new_latch_1/a_82_34# GND nfet w=5 l=2
+  ad=30 pd=22 as=0 ps=0
M2561 Vdd fsm_0/reg1w datapath_0/register_1/register_one_0[5]/new_latch_1/a_82_52# Vdd pfet w=10 l=2
+  ad=0 pd=0 as=60 ps=32
M2562 GND datapath_0/reg2r1 datapath_0/register_1/register_one_0[5]/new_latch_2/a_82_52# GND nfet w=5 l=2
+  ad=0 pd=0 as=30 ps=22
M2563 datapath_0/register_1/register_one_0[5]/new_latch_2/a_99_34# datapath_0/register_1/register_one_0[5]/new_latch_2/a_79_32# Vdd Vdd pfet w=10 l=2
+  ad=40 pd=28 as=0 ps=0
M2564 datapath_0/register_1/register_one_0[5]/new_latch_2/a_79_32# datapath_0/register_1/register_one_0[5]/data Vdd Vdd pfet w=10 l=2
+  ad=60 pd=32 as=0 ps=0
M2565 datapath_0/rx5 datapath_0/register_1/register_one_0[5]/new_latch_2/a_82_52# datapath_0/register_1/register_one_0[5]/new_latch_2/a_99_34# Vdd pfet w=10 l=2
+  ad=0 pd=0 as=0 ps=0
M2566 datapath_0/register_1/register_one_0[5]/new_latch_2/a_82_34# datapath_0/register_1/register_one_0[5]/new_latch_2/a_79_32# GND GND nfet w=5 l=2
+  ad=20 pd=18 as=0 ps=0
M2567 datapath_0/register_1/register_one_0[5]/new_latch_2/a_79_32# datapath_0/register_1/register_one_0[5]/data GND GND nfet w=5 l=2
+  ad=30 pd=22 as=0 ps=0
M2568 datapath_0/rx5 datapath_0/reg2r1 datapath_0/register_1/register_one_0[5]/new_latch_2/a_82_34# GND nfet w=5 l=2
+  ad=0 pd=0 as=0 ps=0
M2569 Vdd datapath_0/reg2r1 datapath_0/register_1/register_one_0[5]/new_latch_2/a_82_52# Vdd pfet w=10 l=2
+  ad=0 pd=0 as=60 ps=32
M2570 GND fsm_0/reg1r1 datapath_0/register_1/register_one_0[5]/new_latch_3/a_82_52# GND nfet w=5 l=2
+  ad=0 pd=0 as=30 ps=22
M2571 datapath_0/register_1/register_one_0[5]/new_latch_3/a_99_34# datapath_0/register_1/register_one_0[5]/new_latch_3/a_79_32# Vdd Vdd pfet w=10 l=2
+  ad=40 pd=28 as=0 ps=0
M2572 datapath_0/register_1/register_one_0[5]/new_latch_3/a_79_32# datapath_0/register_1/register_one_0[5]/data Vdd Vdd pfet w=10 l=2
+  ad=60 pd=32 as=0 ps=0
M2573 datapath_0/ry5 datapath_0/register_1/register_one_0[5]/new_latch_3/a_82_52# datapath_0/register_1/register_one_0[5]/new_latch_3/a_99_34# Vdd pfet w=10 l=2
+  ad=0 pd=0 as=0 ps=0
M2574 datapath_0/register_1/register_one_0[5]/new_latch_3/a_82_34# datapath_0/register_1/register_one_0[5]/new_latch_3/a_79_32# GND GND nfet w=5 l=2
+  ad=20 pd=18 as=0 ps=0
M2575 datapath_0/register_1/register_one_0[5]/new_latch_3/a_79_32# datapath_0/register_1/register_one_0[5]/data GND GND nfet w=5 l=2
+  ad=30 pd=22 as=0 ps=0
M2576 datapath_0/ry5 fsm_0/reg1r1 datapath_0/register_1/register_one_0[5]/new_latch_3/a_82_34# GND nfet w=5 l=2
+  ad=0 pd=0 as=0 ps=0
M2577 Vdd fsm_0/reg1r1 datapath_0/register_1/register_one_0[5]/new_latch_3/a_82_52# Vdd pfet w=10 l=2
+  ad=0 pd=0 as=60 ps=32
M2578 datapath_0/register_1/register_one_0[6]/tp1 datapath_0/register_1/register_one_0[6]/inv_0/in GND GND nfet w=5 l=2
+  ad=60 pd=44 as=0 ps=0
M2579 datapath_0/register_1/register_one_0[6]/tp1 datapath_0/register_1/register_one_0[6]/inv_0/in Vdd Vdd pfet w=10 l=2
+  ad=120 pd=64 as=0 ps=0
M2580 datapath_0/register_1/register_one_0[6]/inv_0/in datapath_0/register_1/register_one_0[6]/data GND GND nfet w=5 l=2
+  ad=30 pd=22 as=0 ps=0
M2581 datapath_0/register_1/register_one_0[6]/inv_0/in datapath_0/register_1/register_one_0[6]/data Vdd Vdd pfet w=10 l=2
+  ad=60 pd=32 as=0 ps=0
M2582 datapath_0/register_1/register_one_0[6]/notw fsm_0/reg1w GND GND nfet w=5 l=2
+  ad=30 pd=22 as=0 ps=0
M2583 datapath_0/register_1/register_one_0[6]/notw fsm_0/reg1w Vdd Vdd pfet w=10 l=2
+  ad=60 pd=32 as=0 ps=0
M2584 GND datapath_0/register_1/register_one_0[6]/notw datapath_0/register_1/register_one_0[6]/new_latch_0/a_82_52# GND nfet w=5 l=2
+  ad=0 pd=0 as=30 ps=22
M2585 datapath_0/register_1/register_one_0[6]/new_latch_0/a_99_34# datapath_0/register_1/register_one_0[6]/new_latch_0/a_79_32# Vdd Vdd pfet w=10 l=2
+  ad=40 pd=28 as=0 ps=0
M2586 datapath_0/register_1/register_one_0[6]/new_latch_0/a_79_32# datapath_0/register_1/register_one_0[6]/data Vdd Vdd pfet w=10 l=2
+  ad=60 pd=32 as=0 ps=0
M2587 datapath_0/register_1/register_one_0[6]/tp1 datapath_0/register_1/register_one_0[6]/new_latch_0/a_82_52# datapath_0/register_1/register_one_0[6]/new_latch_0/a_99_34# Vdd pfet w=10 l=2
+  ad=0 pd=0 as=0 ps=0
M2588 datapath_0/register_1/register_one_0[6]/new_latch_0/a_82_34# datapath_0/register_1/register_one_0[6]/new_latch_0/a_79_32# GND GND nfet w=5 l=2
+  ad=20 pd=18 as=0 ps=0
M2589 datapath_0/register_1/register_one_0[6]/new_latch_0/a_79_32# datapath_0/register_1/register_one_0[6]/data GND GND nfet w=5 l=2
+  ad=30 pd=22 as=0 ps=0
M2590 datapath_0/register_1/register_one_0[6]/tp1 datapath_0/register_1/register_one_0[6]/notw datapath_0/register_1/register_one_0[6]/new_latch_0/a_82_34# GND nfet w=5 l=2
+  ad=0 pd=0 as=0 ps=0
M2591 Vdd datapath_0/register_1/register_one_0[6]/notw datapath_0/register_1/register_one_0[6]/new_latch_0/a_82_52# Vdd pfet w=10 l=2
+  ad=0 pd=0 as=60 ps=32
M2592 GND fsm_0/reg1w datapath_0/register_1/register_one_0[6]/new_latch_1/a_82_52# GND nfet w=5 l=2
+  ad=0 pd=0 as=30 ps=22
M2593 datapath_0/register_1/register_one_0[6]/new_latch_1/a_99_34# datapath_0/register_1/register_one_0[6]/new_latch_1/a_79_32# Vdd Vdd pfet w=10 l=2
+  ad=40 pd=28 as=0 ps=0
M2594 datapath_0/register_1/register_one_0[6]/new_latch_1/a_79_32# datapath_0/wz6 Vdd Vdd pfet w=10 l=2
+  ad=60 pd=32 as=0 ps=0
M2595 datapath_0/register_1/register_one_0[6]/data datapath_0/register_1/register_one_0[6]/new_latch_1/a_82_52# datapath_0/register_1/register_one_0[6]/new_latch_1/a_99_34# Vdd pfet w=10 l=2
+  ad=60 pd=32 as=0 ps=0
M2596 datapath_0/register_1/register_one_0[6]/new_latch_1/a_82_34# datapath_0/register_1/register_one_0[6]/new_latch_1/a_79_32# GND GND nfet w=5 l=2
+  ad=20 pd=18 as=0 ps=0
M2597 datapath_0/register_1/register_one_0[6]/new_latch_1/a_79_32# datapath_0/wz6 GND GND nfet w=5 l=2
+  ad=30 pd=22 as=0 ps=0
M2598 datapath_0/register_1/register_one_0[6]/data fsm_0/reg1w datapath_0/register_1/register_one_0[6]/new_latch_1/a_82_34# GND nfet w=5 l=2
+  ad=30 pd=22 as=0 ps=0
M2599 Vdd fsm_0/reg1w datapath_0/register_1/register_one_0[6]/new_latch_1/a_82_52# Vdd pfet w=10 l=2
+  ad=0 pd=0 as=60 ps=32
M2600 GND datapath_0/reg2r1 datapath_0/register_1/register_one_0[6]/new_latch_2/a_82_52# GND nfet w=5 l=2
+  ad=0 pd=0 as=30 ps=22
M2601 datapath_0/register_1/register_one_0[6]/new_latch_2/a_99_34# datapath_0/register_1/register_one_0[6]/new_latch_2/a_79_32# Vdd Vdd pfet w=10 l=2
+  ad=40 pd=28 as=0 ps=0
M2602 datapath_0/register_1/register_one_0[6]/new_latch_2/a_79_32# datapath_0/register_1/register_one_0[6]/data Vdd Vdd pfet w=10 l=2
+  ad=60 pd=32 as=0 ps=0
M2603 datapath_0/rx6 datapath_0/register_1/register_one_0[6]/new_latch_2/a_82_52# datapath_0/register_1/register_one_0[6]/new_latch_2/a_99_34# Vdd pfet w=10 l=2
+  ad=0 pd=0 as=0 ps=0
M2604 datapath_0/register_1/register_one_0[6]/new_latch_2/a_82_34# datapath_0/register_1/register_one_0[6]/new_latch_2/a_79_32# GND GND nfet w=5 l=2
+  ad=20 pd=18 as=0 ps=0
M2605 datapath_0/register_1/register_one_0[6]/new_latch_2/a_79_32# datapath_0/register_1/register_one_0[6]/data GND GND nfet w=5 l=2
+  ad=30 pd=22 as=0 ps=0
M2606 datapath_0/rx6 datapath_0/reg2r1 datapath_0/register_1/register_one_0[6]/new_latch_2/a_82_34# GND nfet w=5 l=2
+  ad=0 pd=0 as=0 ps=0
M2607 Vdd datapath_0/reg2r1 datapath_0/register_1/register_one_0[6]/new_latch_2/a_82_52# Vdd pfet w=10 l=2
+  ad=0 pd=0 as=60 ps=32
M2608 GND fsm_0/reg1r1 datapath_0/register_1/register_one_0[6]/new_latch_3/a_82_52# GND nfet w=5 l=2
+  ad=0 pd=0 as=30 ps=22
M2609 datapath_0/register_1/register_one_0[6]/new_latch_3/a_99_34# datapath_0/register_1/register_one_0[6]/new_latch_3/a_79_32# Vdd Vdd pfet w=10 l=2
+  ad=40 pd=28 as=0 ps=0
M2610 datapath_0/register_1/register_one_0[6]/new_latch_3/a_79_32# datapath_0/register_1/register_one_0[6]/data Vdd Vdd pfet w=10 l=2
+  ad=60 pd=32 as=0 ps=0
M2611 datapath_0/ry6 datapath_0/register_1/register_one_0[6]/new_latch_3/a_82_52# datapath_0/register_1/register_one_0[6]/new_latch_3/a_99_34# Vdd pfet w=10 l=2
+  ad=0 pd=0 as=0 ps=0
M2612 datapath_0/register_1/register_one_0[6]/new_latch_3/a_82_34# datapath_0/register_1/register_one_0[6]/new_latch_3/a_79_32# GND GND nfet w=5 l=2
+  ad=20 pd=18 as=0 ps=0
M2613 datapath_0/register_1/register_one_0[6]/new_latch_3/a_79_32# datapath_0/register_1/register_one_0[6]/data GND GND nfet w=5 l=2
+  ad=30 pd=22 as=0 ps=0
M2614 datapath_0/ry6 fsm_0/reg1r1 datapath_0/register_1/register_one_0[6]/new_latch_3/a_82_34# GND nfet w=5 l=2
+  ad=0 pd=0 as=0 ps=0
M2615 Vdd fsm_0/reg1r1 datapath_0/register_1/register_one_0[6]/new_latch_3/a_82_52# Vdd pfet w=10 l=2
+  ad=0 pd=0 as=60 ps=32
M2616 datapath_0/register_1/register_one_0[7]/tp1 datapath_0/register_1/register_one_0[7]/inv_0/in GND GND nfet w=5 l=2
+  ad=60 pd=44 as=0 ps=0
M2617 datapath_0/register_1/register_one_0[7]/tp1 datapath_0/register_1/register_one_0[7]/inv_0/in Vdd Vdd pfet w=10 l=2
+  ad=120 pd=64 as=0 ps=0
M2618 datapath_0/register_1/register_one_0[7]/inv_0/in datapath_0/register_1/register_one_0[7]/data GND GND nfet w=5 l=2
+  ad=30 pd=22 as=0 ps=0
M2619 datapath_0/register_1/register_one_0[7]/inv_0/in datapath_0/register_1/register_one_0[7]/data Vdd Vdd pfet w=10 l=2
+  ad=60 pd=32 as=0 ps=0
M2620 datapath_0/register_1/register_one_0[7]/notw fsm_0/reg1w GND GND nfet w=5 l=2
+  ad=30 pd=22 as=0 ps=0
M2621 datapath_0/register_1/register_one_0[7]/notw fsm_0/reg1w Vdd Vdd pfet w=10 l=2
+  ad=60 pd=32 as=0 ps=0
M2622 GND datapath_0/register_1/register_one_0[7]/notw datapath_0/register_1/register_one_0[7]/new_latch_0/a_82_52# GND nfet w=5 l=2
+  ad=0 pd=0 as=30 ps=22
M2623 datapath_0/register_1/register_one_0[7]/new_latch_0/a_99_34# datapath_0/register_1/register_one_0[7]/new_latch_0/a_79_32# Vdd Vdd pfet w=10 l=2
+  ad=40 pd=28 as=0 ps=0
M2624 datapath_0/register_1/register_one_0[7]/new_latch_0/a_79_32# datapath_0/register_1/register_one_0[7]/data Vdd Vdd pfet w=10 l=2
+  ad=60 pd=32 as=0 ps=0
M2625 datapath_0/register_1/register_one_0[7]/tp1 datapath_0/register_1/register_one_0[7]/new_latch_0/a_82_52# datapath_0/register_1/register_one_0[7]/new_latch_0/a_99_34# Vdd pfet w=10 l=2
+  ad=0 pd=0 as=0 ps=0
M2626 datapath_0/register_1/register_one_0[7]/new_latch_0/a_82_34# datapath_0/register_1/register_one_0[7]/new_latch_0/a_79_32# GND GND nfet w=5 l=2
+  ad=20 pd=18 as=0 ps=0
M2627 datapath_0/register_1/register_one_0[7]/new_latch_0/a_79_32# datapath_0/register_1/register_one_0[7]/data GND GND nfet w=5 l=2
+  ad=30 pd=22 as=0 ps=0
M2628 datapath_0/register_1/register_one_0[7]/tp1 datapath_0/register_1/register_one_0[7]/notw datapath_0/register_1/register_one_0[7]/new_latch_0/a_82_34# GND nfet w=5 l=2
+  ad=0 pd=0 as=0 ps=0
M2629 Vdd datapath_0/register_1/register_one_0[7]/notw datapath_0/register_1/register_one_0[7]/new_latch_0/a_82_52# Vdd pfet w=10 l=2
+  ad=0 pd=0 as=60 ps=32
M2630 GND fsm_0/reg1w datapath_0/register_1/register_one_0[7]/new_latch_1/a_82_52# GND nfet w=5 l=2
+  ad=0 pd=0 as=30 ps=22
M2631 datapath_0/register_1/register_one_0[7]/new_latch_1/a_99_34# datapath_0/register_1/register_one_0[7]/new_latch_1/a_79_32# Vdd Vdd pfet w=10 l=2
+  ad=40 pd=28 as=0 ps=0
M2632 datapath_0/register_1/register_one_0[7]/new_latch_1/a_79_32# datapath_0/wz7 Vdd Vdd pfet w=10 l=2
+  ad=60 pd=32 as=0 ps=0
M2633 datapath_0/register_1/register_one_0[7]/data datapath_0/register_1/register_one_0[7]/new_latch_1/a_82_52# datapath_0/register_1/register_one_0[7]/new_latch_1/a_99_34# Vdd pfet w=10 l=2
+  ad=60 pd=32 as=0 ps=0
M2634 datapath_0/register_1/register_one_0[7]/new_latch_1/a_82_34# datapath_0/register_1/register_one_0[7]/new_latch_1/a_79_32# GND GND nfet w=5 l=2
+  ad=20 pd=18 as=0 ps=0
M2635 datapath_0/register_1/register_one_0[7]/new_latch_1/a_79_32# datapath_0/wz7 GND GND nfet w=5 l=2
+  ad=30 pd=22 as=0 ps=0
M2636 datapath_0/register_1/register_one_0[7]/data fsm_0/reg1w datapath_0/register_1/register_one_0[7]/new_latch_1/a_82_34# GND nfet w=5 l=2
+  ad=30 pd=22 as=0 ps=0
M2637 Vdd fsm_0/reg1w datapath_0/register_1/register_one_0[7]/new_latch_1/a_82_52# Vdd pfet w=10 l=2
+  ad=0 pd=0 as=60 ps=32
M2638 GND datapath_0/reg2r1 datapath_0/register_1/register_one_0[7]/new_latch_2/a_82_52# GND nfet w=5 l=2
+  ad=0 pd=0 as=30 ps=22
M2639 datapath_0/register_1/register_one_0[7]/new_latch_2/a_99_34# datapath_0/register_1/register_one_0[7]/new_latch_2/a_79_32# Vdd Vdd pfet w=10 l=2
+  ad=40 pd=28 as=0 ps=0
M2640 datapath_0/register_1/register_one_0[7]/new_latch_2/a_79_32# datapath_0/register_1/register_one_0[7]/data Vdd Vdd pfet w=10 l=2
+  ad=60 pd=32 as=0 ps=0
M2641 datapath_0/rx7 datapath_0/register_1/register_one_0[7]/new_latch_2/a_82_52# datapath_0/register_1/register_one_0[7]/new_latch_2/a_99_34# Vdd pfet w=10 l=2
+  ad=0 pd=0 as=0 ps=0
M2642 datapath_0/register_1/register_one_0[7]/new_latch_2/a_82_34# datapath_0/register_1/register_one_0[7]/new_latch_2/a_79_32# GND GND nfet w=5 l=2
+  ad=20 pd=18 as=0 ps=0
M2643 datapath_0/register_1/register_one_0[7]/new_latch_2/a_79_32# datapath_0/register_1/register_one_0[7]/data GND GND nfet w=5 l=2
+  ad=30 pd=22 as=0 ps=0
M2644 datapath_0/rx7 datapath_0/reg2r1 datapath_0/register_1/register_one_0[7]/new_latch_2/a_82_34# GND nfet w=5 l=2
+  ad=0 pd=0 as=0 ps=0
M2645 Vdd datapath_0/reg2r1 datapath_0/register_1/register_one_0[7]/new_latch_2/a_82_52# Vdd pfet w=10 l=2
+  ad=0 pd=0 as=60 ps=32
M2646 GND fsm_0/reg1r1 datapath_0/register_1/register_one_0[7]/new_latch_3/a_82_52# GND nfet w=5 l=2
+  ad=0 pd=0 as=30 ps=22
M2647 datapath_0/register_1/register_one_0[7]/new_latch_3/a_99_34# datapath_0/register_1/register_one_0[7]/new_latch_3/a_79_32# Vdd Vdd pfet w=10 l=2
+  ad=40 pd=28 as=0 ps=0
M2648 datapath_0/register_1/register_one_0[7]/new_latch_3/a_79_32# datapath_0/register_1/register_one_0[7]/data Vdd Vdd pfet w=10 l=2
+  ad=60 pd=32 as=0 ps=0
M2649 datapath_0/ry7 datapath_0/register_1/register_one_0[7]/new_latch_3/a_82_52# datapath_0/register_1/register_one_0[7]/new_latch_3/a_99_34# Vdd pfet w=10 l=2
+  ad=0 pd=0 as=0 ps=0
M2650 datapath_0/register_1/register_one_0[7]/new_latch_3/a_82_34# datapath_0/register_1/register_one_0[7]/new_latch_3/a_79_32# GND GND nfet w=5 l=2
+  ad=20 pd=18 as=0 ps=0
M2651 datapath_0/register_1/register_one_0[7]/new_latch_3/a_79_32# datapath_0/register_1/register_one_0[7]/data GND GND nfet w=5 l=2
+  ad=30 pd=22 as=0 ps=0
M2652 datapath_0/ry7 fsm_0/reg1r1 datapath_0/register_1/register_one_0[7]/new_latch_3/a_82_34# GND nfet w=5 l=2
+  ad=0 pd=0 as=0 ps=0
M2653 Vdd fsm_0/reg1r1 datapath_0/register_1/register_one_0[7]/new_latch_3/a_82_52# Vdd pfet w=10 l=2
+  ad=0 pd=0 as=60 ps=32
M2654 datapath_0/addsub_0/xor3_0[0]/abar datapath_0/ry0 GND GND nfet w=5 l=2
+  ad=30 pd=22 as=0 ps=0
M2655 datapath_0/addsub_0/xor3_0[0]/abar datapath_0/ry0 Vdd Vdd pfet w=10 l=2
+  ad=60 pd=32 as=0 ps=0
M2656 datapath_0/addsub_0/xor3_0[0]/bbar datapath_0/cin GND GND nfet w=5 l=2
+  ad=30 pd=22 as=0 ps=0
M2657 datapath_0/addsub_0/xor3_0[0]/bbar datapath_0/cin Vdd Vdd pfet w=10 l=2
+  ad=60 pd=32 as=0 ps=0
M2658 datapath_0/addsub_0/xor3_0[0]/out datapath_0/cin datapath_0/addsub_0/xor3_0[0]/a_7_n41# GND nfet w=4 l=5
+  ad=121 pd=68 as=68 ps=42
M2659 GND datapath_0/addsub_0/xor3_0[0]/bbar datapath_0/addsub_0/xor3_0[0]/a_63_n41# GND nfet w=4 l=5
+  ad=0 pd=0 as=52 ps=34
M2660 Vdd datapath_0/cin datapath_0/addsub_0/xor3_0[0]/a_7_n16# Vdd pfet w=5 l=5
+  ad=0 pd=0 as=285 ps=124
M2661 datapath_0/addsub_0/xor3_0[0]/a_63_n41# datapath_0/addsub_0/xor3_0[0]/abar datapath_0/addsub_0/xor3_0[0]/out GND nfet w=4 l=5
+  ad=0 pd=0 as=0 ps=0
M2662 datapath_0/addsub_0/xor3_0[0]/a_7_n16# datapath_0/addsub_0/xor3_0[0]/bbar datapath_0/addsub_0/xor3_0[0]/out Vdd pfet w=10 l=5
+  ad=0 pd=0 as=130 ps=46
M2663 datapath_0/addsub_0/xor3_0[0]/out datapath_0/addsub_0/xor3_0[0]/abar datapath_0/addsub_0/xor3_0[0]/a_7_n16# Vdd pfet w=10 l=5
+  ad=0 pd=0 as=0 ps=0
M2664 datapath_0/addsub_0/xor3_0[0]/a_7_n41# datapath_0/ry0 GND GND nfet w=4 l=5
+  ad=0 pd=0 as=0 ps=0
M2665 datapath_0/addsub_0/xor3_0[0]/a_7_n16# datapath_0/ry0 Vdd Vdd pfet w=5 l=5
+  ad=0 pd=0 as=0 ps=0
M2666 datapath_0/addsub_0/xor3_0[1]/abar datapath_0/ry1 GND GND nfet w=5 l=2
+  ad=30 pd=22 as=0 ps=0
M2667 datapath_0/addsub_0/xor3_0[1]/abar datapath_0/ry1 Vdd Vdd pfet w=10 l=2
+  ad=60 pd=32 as=0 ps=0
M2668 datapath_0/addsub_0/xor3_0[1]/bbar datapath_0/cin GND GND nfet w=5 l=2
+  ad=30 pd=22 as=0 ps=0
M2669 datapath_0/addsub_0/xor3_0[1]/bbar datapath_0/cin Vdd Vdd pfet w=10 l=2
+  ad=60 pd=32 as=0 ps=0
M2670 datapath_0/addsub_0/xor3_0[1]/out datapath_0/cin datapath_0/addsub_0/xor3_0[1]/a_7_n41# GND nfet w=4 l=5
+  ad=121 pd=68 as=68 ps=42
M2671 GND datapath_0/addsub_0/xor3_0[1]/bbar datapath_0/addsub_0/xor3_0[1]/a_63_n41# GND nfet w=4 l=5
+  ad=0 pd=0 as=52 ps=34
M2672 Vdd datapath_0/cin datapath_0/addsub_0/xor3_0[1]/a_7_n16# Vdd pfet w=5 l=5
+  ad=0 pd=0 as=285 ps=124
M2673 datapath_0/addsub_0/xor3_0[1]/a_63_n41# datapath_0/addsub_0/xor3_0[1]/abar datapath_0/addsub_0/xor3_0[1]/out GND nfet w=4 l=5
+  ad=0 pd=0 as=0 ps=0
M2674 datapath_0/addsub_0/xor3_0[1]/a_7_n16# datapath_0/addsub_0/xor3_0[1]/bbar datapath_0/addsub_0/xor3_0[1]/out Vdd pfet w=10 l=5
+  ad=0 pd=0 as=130 ps=46
M2675 datapath_0/addsub_0/xor3_0[1]/out datapath_0/addsub_0/xor3_0[1]/abar datapath_0/addsub_0/xor3_0[1]/a_7_n16# Vdd pfet w=10 l=5
+  ad=0 pd=0 as=0 ps=0
M2676 datapath_0/addsub_0/xor3_0[1]/a_7_n41# datapath_0/ry1 GND GND nfet w=4 l=5
+  ad=0 pd=0 as=0 ps=0
M2677 datapath_0/addsub_0/xor3_0[1]/a_7_n16# datapath_0/ry1 Vdd Vdd pfet w=5 l=5
+  ad=0 pd=0 as=0 ps=0
M2678 datapath_0/addsub_0/xor3_0[2]/abar datapath_0/ry2 GND GND nfet w=5 l=2
+  ad=30 pd=22 as=0 ps=0
M2679 datapath_0/addsub_0/xor3_0[2]/abar datapath_0/ry2 Vdd Vdd pfet w=10 l=2
+  ad=60 pd=32 as=0 ps=0
M2680 datapath_0/addsub_0/xor3_0[2]/bbar datapath_0/cin GND GND nfet w=5 l=2
+  ad=30 pd=22 as=0 ps=0
M2681 datapath_0/addsub_0/xor3_0[2]/bbar datapath_0/cin Vdd Vdd pfet w=10 l=2
+  ad=60 pd=32 as=0 ps=0
M2682 datapath_0/addsub_0/xor3_0[2]/out datapath_0/cin datapath_0/addsub_0/xor3_0[2]/a_7_n41# GND nfet w=4 l=5
+  ad=121 pd=68 as=68 ps=42
M2683 GND datapath_0/addsub_0/xor3_0[2]/bbar datapath_0/addsub_0/xor3_0[2]/a_63_n41# GND nfet w=4 l=5
+  ad=0 pd=0 as=52 ps=34
M2684 Vdd datapath_0/cin datapath_0/addsub_0/xor3_0[2]/a_7_n16# Vdd pfet w=5 l=5
+  ad=0 pd=0 as=285 ps=124
M2685 datapath_0/addsub_0/xor3_0[2]/a_63_n41# datapath_0/addsub_0/xor3_0[2]/abar datapath_0/addsub_0/xor3_0[2]/out GND nfet w=4 l=5
+  ad=0 pd=0 as=0 ps=0
M2686 datapath_0/addsub_0/xor3_0[2]/a_7_n16# datapath_0/addsub_0/xor3_0[2]/bbar datapath_0/addsub_0/xor3_0[2]/out Vdd pfet w=10 l=5
+  ad=0 pd=0 as=130 ps=46
M2687 datapath_0/addsub_0/xor3_0[2]/out datapath_0/addsub_0/xor3_0[2]/abar datapath_0/addsub_0/xor3_0[2]/a_7_n16# Vdd pfet w=10 l=5
+  ad=0 pd=0 as=0 ps=0
M2688 datapath_0/addsub_0/xor3_0[2]/a_7_n41# datapath_0/ry2 GND GND nfet w=4 l=5
+  ad=0 pd=0 as=0 ps=0
M2689 datapath_0/addsub_0/xor3_0[2]/a_7_n16# datapath_0/ry2 Vdd Vdd pfet w=5 l=5
+  ad=0 pd=0 as=0 ps=0
M2690 datapath_0/addsub_0/xor3_0[3]/abar datapath_0/ry3 GND GND nfet w=5 l=2
+  ad=30 pd=22 as=0 ps=0
M2691 datapath_0/addsub_0/xor3_0[3]/abar datapath_0/ry3 Vdd Vdd pfet w=10 l=2
+  ad=60 pd=32 as=0 ps=0
M2692 datapath_0/addsub_0/xor3_0[3]/bbar datapath_0/cin GND GND nfet w=5 l=2
+  ad=30 pd=22 as=0 ps=0
M2693 datapath_0/addsub_0/xor3_0[3]/bbar datapath_0/cin Vdd Vdd pfet w=10 l=2
+  ad=60 pd=32 as=0 ps=0
M2694 datapath_0/addsub_0/xor3_0[3]/out datapath_0/cin datapath_0/addsub_0/xor3_0[3]/a_7_n41# GND nfet w=4 l=5
+  ad=121 pd=68 as=68 ps=42
M2695 GND datapath_0/addsub_0/xor3_0[3]/bbar datapath_0/addsub_0/xor3_0[3]/a_63_n41# GND nfet w=4 l=5
+  ad=0 pd=0 as=52 ps=34
M2696 Vdd datapath_0/cin datapath_0/addsub_0/xor3_0[3]/a_7_n16# Vdd pfet w=5 l=5
+  ad=0 pd=0 as=285 ps=124
M2697 datapath_0/addsub_0/xor3_0[3]/a_63_n41# datapath_0/addsub_0/xor3_0[3]/abar datapath_0/addsub_0/xor3_0[3]/out GND nfet w=4 l=5
+  ad=0 pd=0 as=0 ps=0
M2698 datapath_0/addsub_0/xor3_0[3]/a_7_n16# datapath_0/addsub_0/xor3_0[3]/bbar datapath_0/addsub_0/xor3_0[3]/out Vdd pfet w=10 l=5
+  ad=0 pd=0 as=130 ps=46
M2699 datapath_0/addsub_0/xor3_0[3]/out datapath_0/addsub_0/xor3_0[3]/abar datapath_0/addsub_0/xor3_0[3]/a_7_n16# Vdd pfet w=10 l=5
+  ad=0 pd=0 as=0 ps=0
M2700 datapath_0/addsub_0/xor3_0[3]/a_7_n41# datapath_0/ry3 GND GND nfet w=4 l=5
+  ad=0 pd=0 as=0 ps=0
M2701 datapath_0/addsub_0/xor3_0[3]/a_7_n16# datapath_0/ry3 Vdd Vdd pfet w=5 l=5
+  ad=0 pd=0 as=0 ps=0
M2702 datapath_0/addsub_0/xor3_0[4]/abar datapath_0/ry4 GND GND nfet w=5 l=2
+  ad=30 pd=22 as=0 ps=0
M2703 datapath_0/addsub_0/xor3_0[4]/abar datapath_0/ry4 Vdd Vdd pfet w=10 l=2
+  ad=60 pd=32 as=0 ps=0
M2704 datapath_0/addsub_0/xor3_0[4]/bbar datapath_0/cin GND GND nfet w=5 l=2
+  ad=30 pd=22 as=0 ps=0
M2705 datapath_0/addsub_0/xor3_0[4]/bbar datapath_0/cin Vdd Vdd pfet w=10 l=2
+  ad=60 pd=32 as=0 ps=0
M2706 datapath_0/addsub_0/xor3_0[4]/out datapath_0/cin datapath_0/addsub_0/xor3_0[4]/a_7_n41# GND nfet w=4 l=5
+  ad=121 pd=68 as=68 ps=42
M2707 GND datapath_0/addsub_0/xor3_0[4]/bbar datapath_0/addsub_0/xor3_0[4]/a_63_n41# GND nfet w=4 l=5
+  ad=0 pd=0 as=52 ps=34
M2708 Vdd datapath_0/cin datapath_0/addsub_0/xor3_0[4]/a_7_n16# Vdd pfet w=5 l=5
+  ad=0 pd=0 as=285 ps=124
M2709 datapath_0/addsub_0/xor3_0[4]/a_63_n41# datapath_0/addsub_0/xor3_0[4]/abar datapath_0/addsub_0/xor3_0[4]/out GND nfet w=4 l=5
+  ad=0 pd=0 as=0 ps=0
M2710 datapath_0/addsub_0/xor3_0[4]/a_7_n16# datapath_0/addsub_0/xor3_0[4]/bbar datapath_0/addsub_0/xor3_0[4]/out Vdd pfet w=10 l=5
+  ad=0 pd=0 as=130 ps=46
M2711 datapath_0/addsub_0/xor3_0[4]/out datapath_0/addsub_0/xor3_0[4]/abar datapath_0/addsub_0/xor3_0[4]/a_7_n16# Vdd pfet w=10 l=5
+  ad=0 pd=0 as=0 ps=0
M2712 datapath_0/addsub_0/xor3_0[4]/a_7_n41# datapath_0/ry4 GND GND nfet w=4 l=5
+  ad=0 pd=0 as=0 ps=0
M2713 datapath_0/addsub_0/xor3_0[4]/a_7_n16# datapath_0/ry4 Vdd Vdd pfet w=5 l=5
+  ad=0 pd=0 as=0 ps=0
M2714 datapath_0/addsub_0/xor3_0[5]/abar datapath_0/ry5 GND GND nfet w=5 l=2
+  ad=30 pd=22 as=0 ps=0
M2715 datapath_0/addsub_0/xor3_0[5]/abar datapath_0/ry5 Vdd Vdd pfet w=10 l=2
+  ad=60 pd=32 as=0 ps=0
M2716 datapath_0/addsub_0/xor3_0[5]/bbar datapath_0/cin GND GND nfet w=5 l=2
+  ad=30 pd=22 as=0 ps=0
M2717 datapath_0/addsub_0/xor3_0[5]/bbar datapath_0/cin Vdd Vdd pfet w=10 l=2
+  ad=60 pd=32 as=0 ps=0
M2718 datapath_0/addsub_0/xor3_0[5]/out datapath_0/cin datapath_0/addsub_0/xor3_0[5]/a_7_n41# GND nfet w=4 l=5
+  ad=121 pd=68 as=68 ps=42
M2719 GND datapath_0/addsub_0/xor3_0[5]/bbar datapath_0/addsub_0/xor3_0[5]/a_63_n41# GND nfet w=4 l=5
+  ad=0 pd=0 as=52 ps=34
M2720 Vdd datapath_0/cin datapath_0/addsub_0/xor3_0[5]/a_7_n16# Vdd pfet w=5 l=5
+  ad=0 pd=0 as=285 ps=124
M2721 datapath_0/addsub_0/xor3_0[5]/a_63_n41# datapath_0/addsub_0/xor3_0[5]/abar datapath_0/addsub_0/xor3_0[5]/out GND nfet w=4 l=5
+  ad=0 pd=0 as=0 ps=0
M2722 datapath_0/addsub_0/xor3_0[5]/a_7_n16# datapath_0/addsub_0/xor3_0[5]/bbar datapath_0/addsub_0/xor3_0[5]/out Vdd pfet w=10 l=5
+  ad=0 pd=0 as=130 ps=46
M2723 datapath_0/addsub_0/xor3_0[5]/out datapath_0/addsub_0/xor3_0[5]/abar datapath_0/addsub_0/xor3_0[5]/a_7_n16# Vdd pfet w=10 l=5
+  ad=0 pd=0 as=0 ps=0
M2724 datapath_0/addsub_0/xor3_0[5]/a_7_n41# datapath_0/ry5 GND GND nfet w=4 l=5
+  ad=0 pd=0 as=0 ps=0
M2725 datapath_0/addsub_0/xor3_0[5]/a_7_n16# datapath_0/ry5 Vdd Vdd pfet w=5 l=5
+  ad=0 pd=0 as=0 ps=0
M2726 datapath_0/addsub_0/xor3_0[6]/abar datapath_0/ry6 GND GND nfet w=5 l=2
+  ad=30 pd=22 as=0 ps=0
M2727 datapath_0/addsub_0/xor3_0[6]/abar datapath_0/ry6 Vdd Vdd pfet w=10 l=2
+  ad=60 pd=32 as=0 ps=0
M2728 datapath_0/addsub_0/xor3_0[6]/bbar datapath_0/cin GND GND nfet w=5 l=2
+  ad=30 pd=22 as=0 ps=0
M2729 datapath_0/addsub_0/xor3_0[6]/bbar datapath_0/cin Vdd Vdd pfet w=10 l=2
+  ad=60 pd=32 as=0 ps=0
M2730 datapath_0/addsub_0/xor3_0[6]/out datapath_0/cin datapath_0/addsub_0/xor3_0[6]/a_7_n41# GND nfet w=4 l=5
+  ad=121 pd=68 as=68 ps=42
M2731 GND datapath_0/addsub_0/xor3_0[6]/bbar datapath_0/addsub_0/xor3_0[6]/a_63_n41# GND nfet w=4 l=5
+  ad=0 pd=0 as=52 ps=34
M2732 Vdd datapath_0/cin datapath_0/addsub_0/xor3_0[6]/a_7_n16# Vdd pfet w=5 l=5
+  ad=0 pd=0 as=285 ps=124
M2733 datapath_0/addsub_0/xor3_0[6]/a_63_n41# datapath_0/addsub_0/xor3_0[6]/abar datapath_0/addsub_0/xor3_0[6]/out GND nfet w=4 l=5
+  ad=0 pd=0 as=0 ps=0
M2734 datapath_0/addsub_0/xor3_0[6]/a_7_n16# datapath_0/addsub_0/xor3_0[6]/bbar datapath_0/addsub_0/xor3_0[6]/out Vdd pfet w=10 l=5
+  ad=0 pd=0 as=130 ps=46
M2735 datapath_0/addsub_0/xor3_0[6]/out datapath_0/addsub_0/xor3_0[6]/abar datapath_0/addsub_0/xor3_0[6]/a_7_n16# Vdd pfet w=10 l=5
+  ad=0 pd=0 as=0 ps=0
M2736 datapath_0/addsub_0/xor3_0[6]/a_7_n41# datapath_0/ry6 GND GND nfet w=4 l=5
+  ad=0 pd=0 as=0 ps=0
M2737 datapath_0/addsub_0/xor3_0[6]/a_7_n16# datapath_0/ry6 Vdd Vdd pfet w=5 l=5
+  ad=0 pd=0 as=0 ps=0
M2738 datapath_0/addsub_0/xor3_0[7]/abar datapath_0/ry7 GND GND nfet w=5 l=2
+  ad=30 pd=22 as=0 ps=0
M2739 datapath_0/addsub_0/xor3_0[7]/abar datapath_0/ry7 Vdd Vdd pfet w=10 l=2
+  ad=60 pd=32 as=0 ps=0
M2740 datapath_0/addsub_0/xor3_0[7]/bbar datapath_0/cin GND GND nfet w=5 l=2
+  ad=30 pd=22 as=0 ps=0
M2741 datapath_0/addsub_0/xor3_0[7]/bbar datapath_0/cin Vdd Vdd pfet w=10 l=2
+  ad=60 pd=32 as=0 ps=0
M2742 datapath_0/addsub_0/xor3_0[7]/out datapath_0/cin datapath_0/addsub_0/xor3_0[7]/a_7_n41# GND nfet w=4 l=5
+  ad=121 pd=68 as=68 ps=42
M2743 GND datapath_0/addsub_0/xor3_0[7]/bbar datapath_0/addsub_0/xor3_0[7]/a_63_n41# GND nfet w=4 l=5
+  ad=0 pd=0 as=52 ps=34
M2744 Vdd datapath_0/cin datapath_0/addsub_0/xor3_0[7]/a_7_n16# Vdd pfet w=5 l=5
+  ad=0 pd=0 as=285 ps=124
M2745 datapath_0/addsub_0/xor3_0[7]/a_63_n41# datapath_0/addsub_0/xor3_0[7]/abar datapath_0/addsub_0/xor3_0[7]/out GND nfet w=4 l=5
+  ad=0 pd=0 as=0 ps=0
M2746 datapath_0/addsub_0/xor3_0[7]/a_7_n16# datapath_0/addsub_0/xor3_0[7]/bbar datapath_0/addsub_0/xor3_0[7]/out Vdd pfet w=10 l=5
+  ad=0 pd=0 as=130 ps=46
M2747 datapath_0/addsub_0/xor3_0[7]/out datapath_0/addsub_0/xor3_0[7]/abar datapath_0/addsub_0/xor3_0[7]/a_7_n16# Vdd pfet w=10 l=5
+  ad=0 pd=0 as=0 ps=0
M2748 datapath_0/addsub_0/xor3_0[7]/a_7_n41# datapath_0/ry7 GND GND nfet w=4 l=5
+  ad=0 pd=0 as=0 ps=0
M2749 datapath_0/addsub_0/xor3_0[7]/a_7_n16# datapath_0/ry7 Vdd Vdd pfet w=5 l=5
+  ad=0 pd=0 as=0 ps=0
M2750 datapath_0/addsub_0/fulladder_0/addsub_one_0[0]/xor3_0/abar datapath_0/cin GND GND nfet w=5 l=2
+  ad=30 pd=22 as=0 ps=0
M2751 datapath_0/addsub_0/fulladder_0/addsub_one_0[0]/xor3_0/abar datapath_0/cin Vdd Vdd pfet w=10 l=2
+  ad=60 pd=32 as=0 ps=0
M2752 datapath_0/addsub_0/fulladder_0/addsub_one_0[0]/xor3_0/bbar datapath_0/addsub_0/fulladder_0/addsub_one_0[0]/T_xor_b GND GND nfet w=5 l=2
+  ad=30 pd=22 as=0 ps=0
M2753 datapath_0/addsub_0/fulladder_0/addsub_one_0[0]/xor3_0/bbar datapath_0/addsub_0/fulladder_0/addsub_one_0[0]/T_xor_b Vdd Vdd pfet w=10 l=2
+  ad=60 pd=32 as=0 ps=0
M2754 datapath_0/latch_2/in0 datapath_0/addsub_0/fulladder_0/addsub_one_0[0]/T_xor_b datapath_0/addsub_0/fulladder_0/addsub_one_0[0]/xor3_0/a_7_n41# GND nfet w=4 l=5
+  ad=121 pd=68 as=68 ps=42
M2755 GND datapath_0/addsub_0/fulladder_0/addsub_one_0[0]/xor3_0/bbar datapath_0/addsub_0/fulladder_0/addsub_one_0[0]/xor3_0/a_63_n41# GND nfet w=4 l=5
+  ad=0 pd=0 as=52 ps=34
M2756 Vdd datapath_0/addsub_0/fulladder_0/addsub_one_0[0]/T_xor_b datapath_0/addsub_0/fulladder_0/addsub_one_0[0]/xor3_0/a_7_n16# Vdd pfet w=5 l=5
+  ad=0 pd=0 as=285 ps=124
M2757 datapath_0/addsub_0/fulladder_0/addsub_one_0[0]/xor3_0/a_63_n41# datapath_0/addsub_0/fulladder_0/addsub_one_0[0]/xor3_0/abar datapath_0/latch_2/in0 GND nfet w=4 l=5
+  ad=0 pd=0 as=0 ps=0
M2758 datapath_0/addsub_0/fulladder_0/addsub_one_0[0]/xor3_0/a_7_n16# datapath_0/addsub_0/fulladder_0/addsub_one_0[0]/xor3_0/bbar datapath_0/latch_2/in0 Vdd pfet w=10 l=5
+  ad=0 pd=0 as=130 ps=46
M2759 datapath_0/latch_2/in0 datapath_0/addsub_0/fulladder_0/addsub_one_0[0]/xor3_0/abar datapath_0/addsub_0/fulladder_0/addsub_one_0[0]/xor3_0/a_7_n16# Vdd pfet w=10 l=5
+  ad=0 pd=0 as=0 ps=0
M2760 datapath_0/addsub_0/fulladder_0/addsub_one_0[0]/xor3_0/a_7_n41# datapath_0/cin GND GND nfet w=4 l=5
+  ad=0 pd=0 as=0 ps=0
M2761 datapath_0/addsub_0/fulladder_0/addsub_one_0[0]/xor3_0/a_7_n16# datapath_0/cin Vdd Vdd pfet w=5 l=5
+  ad=0 pd=0 as=0 ps=0
M2762 datapath_0/addsub_0/fulladder_0/addsub_one_0[0]/xor3_1/abar datapath_0/rx0 GND GND nfet w=5 l=2
+  ad=30 pd=22 as=0 ps=0
M2763 datapath_0/addsub_0/fulladder_0/addsub_one_0[0]/xor3_1/abar datapath_0/rx0 Vdd Vdd pfet w=10 l=2
+  ad=60 pd=32 as=0 ps=0
M2764 datapath_0/addsub_0/fulladder_0/addsub_one_0[0]/xor3_1/bbar datapath_0/addsub_0/xor3_0[0]/out GND GND nfet w=5 l=2
+  ad=30 pd=22 as=0 ps=0
M2765 datapath_0/addsub_0/fulladder_0/addsub_one_0[0]/xor3_1/bbar datapath_0/addsub_0/xor3_0[0]/out Vdd Vdd pfet w=10 l=2
+  ad=60 pd=32 as=0 ps=0
M2766 datapath_0/addsub_0/fulladder_0/addsub_one_0[0]/T_xor_b datapath_0/addsub_0/xor3_0[0]/out datapath_0/addsub_0/fulladder_0/addsub_one_0[0]/xor3_1/a_7_n41# GND nfet w=4 l=5
+  ad=121 pd=68 as=68 ps=42
M2767 GND datapath_0/addsub_0/fulladder_0/addsub_one_0[0]/xor3_1/bbar datapath_0/addsub_0/fulladder_0/addsub_one_0[0]/xor3_1/a_63_n41# GND nfet w=4 l=5
+  ad=0 pd=0 as=52 ps=34
M2768 Vdd datapath_0/addsub_0/xor3_0[0]/out datapath_0/addsub_0/fulladder_0/addsub_one_0[0]/xor3_1/a_7_n16# Vdd pfet w=5 l=5
+  ad=0 pd=0 as=285 ps=124
M2769 datapath_0/addsub_0/fulladder_0/addsub_one_0[0]/xor3_1/a_63_n41# datapath_0/addsub_0/fulladder_0/addsub_one_0[0]/xor3_1/abar datapath_0/addsub_0/fulladder_0/addsub_one_0[0]/T_xor_b GND nfet w=4 l=5
+  ad=0 pd=0 as=0 ps=0
M2770 datapath_0/addsub_0/fulladder_0/addsub_one_0[0]/xor3_1/a_7_n16# datapath_0/addsub_0/fulladder_0/addsub_one_0[0]/xor3_1/bbar datapath_0/addsub_0/fulladder_0/addsub_one_0[0]/T_xor_b Vdd pfet w=10 l=5
+  ad=0 pd=0 as=130 ps=46
M2771 datapath_0/addsub_0/fulladder_0/addsub_one_0[0]/T_xor_b datapath_0/addsub_0/fulladder_0/addsub_one_0[0]/xor3_1/abar datapath_0/addsub_0/fulladder_0/addsub_one_0[0]/xor3_1/a_7_n16# Vdd pfet w=10 l=5
+  ad=0 pd=0 as=0 ps=0
M2772 datapath_0/addsub_0/fulladder_0/addsub_one_0[0]/xor3_1/a_7_n41# datapath_0/rx0 GND GND nfet w=4 l=5
+  ad=0 pd=0 as=0 ps=0
M2773 datapath_0/addsub_0/fulladder_0/addsub_one_0[0]/xor3_1/a_7_n16# datapath_0/rx0 Vdd Vdd pfet w=5 l=5
+  ad=0 pd=0 as=0 ps=0
M2774 datapath_0/addsub_0/fulladder_0/addsub_one_0[0]/nand2_2/a_7_10# datapath_0/cin GND GND nfet w=6 l=2
+  ad=42 pd=26 as=0 ps=0
M2775 datapath_0/addsub_0/fulladder_0/addsub_one_0[0]/nand2_3/B datapath_0/cin Vdd Vdd pfet w=12 l=2
+  ad=84 pd=38 as=0 ps=0
M2776 datapath_0/addsub_0/fulladder_0/addsub_one_0[0]/nand2_3/B datapath_0/addsub_0/fulladder_0/addsub_one_0[0]/T_xor_b datapath_0/addsub_0/fulladder_0/addsub_one_0[0]/nand2_2/a_7_10# GND nfet w=6 l=2
+  ad=36 pd=24 as=0 ps=0
M2777 Vdd datapath_0/addsub_0/fulladder_0/addsub_one_0[0]/T_xor_b datapath_0/addsub_0/fulladder_0/addsub_one_0[0]/nand2_3/B Vdd pfet w=12 l=2
+  ad=0 pd=0 as=0 ps=0
M2778 datapath_0/addsub_0/fulladder_0/addsub_one_0[0]/nand2_3/a_7_10# datapath_0/addsub_0/fulladder_0/addsub_one_0[0]/nand2_3/A GND GND nfet w=6 l=2
+  ad=42 pd=26 as=0 ps=0
M2779 datapath_0/addsub_0/fulladder_0/addsub_one_0[1]/cin datapath_0/addsub_0/fulladder_0/addsub_one_0[0]/nand2_3/A Vdd Vdd pfet w=12 l=2
+  ad=84 pd=38 as=0 ps=0
M2780 datapath_0/addsub_0/fulladder_0/addsub_one_0[1]/cin datapath_0/addsub_0/fulladder_0/addsub_one_0[0]/nand2_3/B datapath_0/addsub_0/fulladder_0/addsub_one_0[0]/nand2_3/a_7_10# GND nfet w=6 l=2
+  ad=36 pd=24 as=0 ps=0
M2781 Vdd datapath_0/addsub_0/fulladder_0/addsub_one_0[0]/nand2_3/B datapath_0/addsub_0/fulladder_0/addsub_one_0[1]/cin Vdd pfet w=12 l=2
+  ad=0 pd=0 as=0 ps=0
M2782 datapath_0/addsub_0/fulladder_0/addsub_one_0[0]/nand2_4/a_7_10# datapath_0/rx0 GND GND nfet w=6 l=2
+  ad=42 pd=26 as=0 ps=0
M2783 datapath_0/addsub_0/fulladder_0/addsub_one_0[0]/nand2_3/A datapath_0/rx0 Vdd Vdd pfet w=12 l=2
+  ad=84 pd=38 as=0 ps=0
M2784 datapath_0/addsub_0/fulladder_0/addsub_one_0[0]/nand2_3/A datapath_0/addsub_0/xor3_0[0]/out datapath_0/addsub_0/fulladder_0/addsub_one_0[0]/nand2_4/a_7_10# GND nfet w=6 l=2
+  ad=36 pd=24 as=0 ps=0
M2785 Vdd datapath_0/addsub_0/xor3_0[0]/out datapath_0/addsub_0/fulladder_0/addsub_one_0[0]/nand2_3/A Vdd pfet w=12 l=2
+  ad=0 pd=0 as=0 ps=0
M2786 datapath_0/addsub_0/fulladder_0/addsub_one_0[1]/xor3_0/abar datapath_0/addsub_0/fulladder_0/addsub_one_0[1]/cin GND GND nfet w=5 l=2
+  ad=30 pd=22 as=0 ps=0
M2787 datapath_0/addsub_0/fulladder_0/addsub_one_0[1]/xor3_0/abar datapath_0/addsub_0/fulladder_0/addsub_one_0[1]/cin Vdd Vdd pfet w=10 l=2
+  ad=60 pd=32 as=0 ps=0
M2788 datapath_0/addsub_0/fulladder_0/addsub_one_0[1]/xor3_0/bbar datapath_0/addsub_0/fulladder_0/addsub_one_0[1]/T_xor_b GND GND nfet w=5 l=2
+  ad=30 pd=22 as=0 ps=0
M2789 datapath_0/addsub_0/fulladder_0/addsub_one_0[1]/xor3_0/bbar datapath_0/addsub_0/fulladder_0/addsub_one_0[1]/T_xor_b Vdd Vdd pfet w=10 l=2
+  ad=60 pd=32 as=0 ps=0
M2790 datapath_0/latch_2/in1 datapath_0/addsub_0/fulladder_0/addsub_one_0[1]/T_xor_b datapath_0/addsub_0/fulladder_0/addsub_one_0[1]/xor3_0/a_7_n41# GND nfet w=4 l=5
+  ad=121 pd=68 as=68 ps=42
M2791 GND datapath_0/addsub_0/fulladder_0/addsub_one_0[1]/xor3_0/bbar datapath_0/addsub_0/fulladder_0/addsub_one_0[1]/xor3_0/a_63_n41# GND nfet w=4 l=5
+  ad=0 pd=0 as=52 ps=34
M2792 Vdd datapath_0/addsub_0/fulladder_0/addsub_one_0[1]/T_xor_b datapath_0/addsub_0/fulladder_0/addsub_one_0[1]/xor3_0/a_7_n16# Vdd pfet w=5 l=5
+  ad=0 pd=0 as=285 ps=124
M2793 datapath_0/addsub_0/fulladder_0/addsub_one_0[1]/xor3_0/a_63_n41# datapath_0/addsub_0/fulladder_0/addsub_one_0[1]/xor3_0/abar datapath_0/latch_2/in1 GND nfet w=4 l=5
+  ad=0 pd=0 as=0 ps=0
M2794 datapath_0/addsub_0/fulladder_0/addsub_one_0[1]/xor3_0/a_7_n16# datapath_0/addsub_0/fulladder_0/addsub_one_0[1]/xor3_0/bbar datapath_0/latch_2/in1 Vdd pfet w=10 l=5
+  ad=0 pd=0 as=130 ps=46
M2795 datapath_0/latch_2/in1 datapath_0/addsub_0/fulladder_0/addsub_one_0[1]/xor3_0/abar datapath_0/addsub_0/fulladder_0/addsub_one_0[1]/xor3_0/a_7_n16# Vdd pfet w=10 l=5
+  ad=0 pd=0 as=0 ps=0
M2796 datapath_0/addsub_0/fulladder_0/addsub_one_0[1]/xor3_0/a_7_n41# datapath_0/addsub_0/fulladder_0/addsub_one_0[1]/cin GND GND nfet w=4 l=5
+  ad=0 pd=0 as=0 ps=0
M2797 datapath_0/addsub_0/fulladder_0/addsub_one_0[1]/xor3_0/a_7_n16# datapath_0/addsub_0/fulladder_0/addsub_one_0[1]/cin Vdd Vdd pfet w=5 l=5
+  ad=0 pd=0 as=0 ps=0
M2798 datapath_0/addsub_0/fulladder_0/addsub_one_0[1]/xor3_1/abar datapath_0/rx1 GND GND nfet w=5 l=2
+  ad=30 pd=22 as=0 ps=0
M2799 datapath_0/addsub_0/fulladder_0/addsub_one_0[1]/xor3_1/abar datapath_0/rx1 Vdd Vdd pfet w=10 l=2
+  ad=60 pd=32 as=0 ps=0
M2800 datapath_0/addsub_0/fulladder_0/addsub_one_0[1]/xor3_1/bbar datapath_0/addsub_0/xor3_0[1]/out GND GND nfet w=5 l=2
+  ad=30 pd=22 as=0 ps=0
M2801 datapath_0/addsub_0/fulladder_0/addsub_one_0[1]/xor3_1/bbar datapath_0/addsub_0/xor3_0[1]/out Vdd Vdd pfet w=10 l=2
+  ad=60 pd=32 as=0 ps=0
M2802 datapath_0/addsub_0/fulladder_0/addsub_one_0[1]/T_xor_b datapath_0/addsub_0/xor3_0[1]/out datapath_0/addsub_0/fulladder_0/addsub_one_0[1]/xor3_1/a_7_n41# GND nfet w=4 l=5
+  ad=121 pd=68 as=68 ps=42
M2803 GND datapath_0/addsub_0/fulladder_0/addsub_one_0[1]/xor3_1/bbar datapath_0/addsub_0/fulladder_0/addsub_one_0[1]/xor3_1/a_63_n41# GND nfet w=4 l=5
+  ad=0 pd=0 as=52 ps=34
M2804 Vdd datapath_0/addsub_0/xor3_0[1]/out datapath_0/addsub_0/fulladder_0/addsub_one_0[1]/xor3_1/a_7_n16# Vdd pfet w=5 l=5
+  ad=0 pd=0 as=285 ps=124
M2805 datapath_0/addsub_0/fulladder_0/addsub_one_0[1]/xor3_1/a_63_n41# datapath_0/addsub_0/fulladder_0/addsub_one_0[1]/xor3_1/abar datapath_0/addsub_0/fulladder_0/addsub_one_0[1]/T_xor_b GND nfet w=4 l=5
+  ad=0 pd=0 as=0 ps=0
M2806 datapath_0/addsub_0/fulladder_0/addsub_one_0[1]/xor3_1/a_7_n16# datapath_0/addsub_0/fulladder_0/addsub_one_0[1]/xor3_1/bbar datapath_0/addsub_0/fulladder_0/addsub_one_0[1]/T_xor_b Vdd pfet w=10 l=5
+  ad=0 pd=0 as=130 ps=46
M2807 datapath_0/addsub_0/fulladder_0/addsub_one_0[1]/T_xor_b datapath_0/addsub_0/fulladder_0/addsub_one_0[1]/xor3_1/abar datapath_0/addsub_0/fulladder_0/addsub_one_0[1]/xor3_1/a_7_n16# Vdd pfet w=10 l=5
+  ad=0 pd=0 as=0 ps=0
M2808 datapath_0/addsub_0/fulladder_0/addsub_one_0[1]/xor3_1/a_7_n41# datapath_0/rx1 GND GND nfet w=4 l=5
+  ad=0 pd=0 as=0 ps=0
M2809 datapath_0/addsub_0/fulladder_0/addsub_one_0[1]/xor3_1/a_7_n16# datapath_0/rx1 Vdd Vdd pfet w=5 l=5
+  ad=0 pd=0 as=0 ps=0
M2810 datapath_0/addsub_0/fulladder_0/addsub_one_0[1]/nand2_2/a_7_10# datapath_0/addsub_0/fulladder_0/addsub_one_0[1]/cin GND GND nfet w=6 l=2
+  ad=42 pd=26 as=0 ps=0
M2811 datapath_0/addsub_0/fulladder_0/addsub_one_0[1]/nand2_3/B datapath_0/addsub_0/fulladder_0/addsub_one_0[1]/cin Vdd Vdd pfet w=12 l=2
+  ad=84 pd=38 as=0 ps=0
M2812 datapath_0/addsub_0/fulladder_0/addsub_one_0[1]/nand2_3/B datapath_0/addsub_0/fulladder_0/addsub_one_0[1]/T_xor_b datapath_0/addsub_0/fulladder_0/addsub_one_0[1]/nand2_2/a_7_10# GND nfet w=6 l=2
+  ad=36 pd=24 as=0 ps=0
M2813 Vdd datapath_0/addsub_0/fulladder_0/addsub_one_0[1]/T_xor_b datapath_0/addsub_0/fulladder_0/addsub_one_0[1]/nand2_3/B Vdd pfet w=12 l=2
+  ad=0 pd=0 as=0 ps=0
M2814 datapath_0/addsub_0/fulladder_0/addsub_one_0[1]/nand2_3/a_7_10# datapath_0/addsub_0/fulladder_0/addsub_one_0[1]/nand2_3/A GND GND nfet w=6 l=2
+  ad=42 pd=26 as=0 ps=0
M2815 datapath_0/addsub_0/fulladder_0/addsub_one_0[2]/cin datapath_0/addsub_0/fulladder_0/addsub_one_0[1]/nand2_3/A Vdd Vdd pfet w=12 l=2
+  ad=84 pd=38 as=0 ps=0
M2816 datapath_0/addsub_0/fulladder_0/addsub_one_0[2]/cin datapath_0/addsub_0/fulladder_0/addsub_one_0[1]/nand2_3/B datapath_0/addsub_0/fulladder_0/addsub_one_0[1]/nand2_3/a_7_10# GND nfet w=6 l=2
+  ad=36 pd=24 as=0 ps=0
M2817 Vdd datapath_0/addsub_0/fulladder_0/addsub_one_0[1]/nand2_3/B datapath_0/addsub_0/fulladder_0/addsub_one_0[2]/cin Vdd pfet w=12 l=2
+  ad=0 pd=0 as=0 ps=0
M2818 datapath_0/addsub_0/fulladder_0/addsub_one_0[1]/nand2_4/a_7_10# datapath_0/rx1 GND GND nfet w=6 l=2
+  ad=42 pd=26 as=0 ps=0
M2819 datapath_0/addsub_0/fulladder_0/addsub_one_0[1]/nand2_3/A datapath_0/rx1 Vdd Vdd pfet w=12 l=2
+  ad=84 pd=38 as=0 ps=0
M2820 datapath_0/addsub_0/fulladder_0/addsub_one_0[1]/nand2_3/A datapath_0/addsub_0/xor3_0[1]/out datapath_0/addsub_0/fulladder_0/addsub_one_0[1]/nand2_4/a_7_10# GND nfet w=6 l=2
+  ad=36 pd=24 as=0 ps=0
M2821 Vdd datapath_0/addsub_0/xor3_0[1]/out datapath_0/addsub_0/fulladder_0/addsub_one_0[1]/nand2_3/A Vdd pfet w=12 l=2
+  ad=0 pd=0 as=0 ps=0
M2822 datapath_0/addsub_0/fulladder_0/addsub_one_0[2]/xor3_0/abar datapath_0/addsub_0/fulladder_0/addsub_one_0[2]/cin GND GND nfet w=5 l=2
+  ad=30 pd=22 as=0 ps=0
M2823 datapath_0/addsub_0/fulladder_0/addsub_one_0[2]/xor3_0/abar datapath_0/addsub_0/fulladder_0/addsub_one_0[2]/cin Vdd Vdd pfet w=10 l=2
+  ad=60 pd=32 as=0 ps=0
M2824 datapath_0/addsub_0/fulladder_0/addsub_one_0[2]/xor3_0/bbar datapath_0/addsub_0/fulladder_0/addsub_one_0[2]/T_xor_b GND GND nfet w=5 l=2
+  ad=30 pd=22 as=0 ps=0
M2825 datapath_0/addsub_0/fulladder_0/addsub_one_0[2]/xor3_0/bbar datapath_0/addsub_0/fulladder_0/addsub_one_0[2]/T_xor_b Vdd Vdd pfet w=10 l=2
+  ad=60 pd=32 as=0 ps=0
M2826 datapath_0/latch_2/in2 datapath_0/addsub_0/fulladder_0/addsub_one_0[2]/T_xor_b datapath_0/addsub_0/fulladder_0/addsub_one_0[2]/xor3_0/a_7_n41# GND nfet w=4 l=5
+  ad=121 pd=68 as=68 ps=42
M2827 GND datapath_0/addsub_0/fulladder_0/addsub_one_0[2]/xor3_0/bbar datapath_0/addsub_0/fulladder_0/addsub_one_0[2]/xor3_0/a_63_n41# GND nfet w=4 l=5
+  ad=0 pd=0 as=52 ps=34
M2828 Vdd datapath_0/addsub_0/fulladder_0/addsub_one_0[2]/T_xor_b datapath_0/addsub_0/fulladder_0/addsub_one_0[2]/xor3_0/a_7_n16# Vdd pfet w=5 l=5
+  ad=0 pd=0 as=285 ps=124
M2829 datapath_0/addsub_0/fulladder_0/addsub_one_0[2]/xor3_0/a_63_n41# datapath_0/addsub_0/fulladder_0/addsub_one_0[2]/xor3_0/abar datapath_0/latch_2/in2 GND nfet w=4 l=5
+  ad=0 pd=0 as=0 ps=0
M2830 datapath_0/addsub_0/fulladder_0/addsub_one_0[2]/xor3_0/a_7_n16# datapath_0/addsub_0/fulladder_0/addsub_one_0[2]/xor3_0/bbar datapath_0/latch_2/in2 Vdd pfet w=10 l=5
+  ad=0 pd=0 as=130 ps=46
M2831 datapath_0/latch_2/in2 datapath_0/addsub_0/fulladder_0/addsub_one_0[2]/xor3_0/abar datapath_0/addsub_0/fulladder_0/addsub_one_0[2]/xor3_0/a_7_n16# Vdd pfet w=10 l=5
+  ad=0 pd=0 as=0 ps=0
M2832 datapath_0/addsub_0/fulladder_0/addsub_one_0[2]/xor3_0/a_7_n41# datapath_0/addsub_0/fulladder_0/addsub_one_0[2]/cin GND GND nfet w=4 l=5
+  ad=0 pd=0 as=0 ps=0
M2833 datapath_0/addsub_0/fulladder_0/addsub_one_0[2]/xor3_0/a_7_n16# datapath_0/addsub_0/fulladder_0/addsub_one_0[2]/cin Vdd Vdd pfet w=5 l=5
+  ad=0 pd=0 as=0 ps=0
M2834 datapath_0/addsub_0/fulladder_0/addsub_one_0[2]/xor3_1/abar datapath_0/rx2 GND GND nfet w=5 l=2
+  ad=30 pd=22 as=0 ps=0
M2835 datapath_0/addsub_0/fulladder_0/addsub_one_0[2]/xor3_1/abar datapath_0/rx2 Vdd Vdd pfet w=10 l=2
+  ad=60 pd=32 as=0 ps=0
M2836 datapath_0/addsub_0/fulladder_0/addsub_one_0[2]/xor3_1/bbar datapath_0/addsub_0/xor3_0[2]/out GND GND nfet w=5 l=2
+  ad=30 pd=22 as=0 ps=0
M2837 datapath_0/addsub_0/fulladder_0/addsub_one_0[2]/xor3_1/bbar datapath_0/addsub_0/xor3_0[2]/out Vdd Vdd pfet w=10 l=2
+  ad=60 pd=32 as=0 ps=0
M2838 datapath_0/addsub_0/fulladder_0/addsub_one_0[2]/T_xor_b datapath_0/addsub_0/xor3_0[2]/out datapath_0/addsub_0/fulladder_0/addsub_one_0[2]/xor3_1/a_7_n41# GND nfet w=4 l=5
+  ad=121 pd=68 as=68 ps=42
M2839 GND datapath_0/addsub_0/fulladder_0/addsub_one_0[2]/xor3_1/bbar datapath_0/addsub_0/fulladder_0/addsub_one_0[2]/xor3_1/a_63_n41# GND nfet w=4 l=5
+  ad=0 pd=0 as=52 ps=34
M2840 Vdd datapath_0/addsub_0/xor3_0[2]/out datapath_0/addsub_0/fulladder_0/addsub_one_0[2]/xor3_1/a_7_n16# Vdd pfet w=5 l=5
+  ad=0 pd=0 as=285 ps=124
M2841 datapath_0/addsub_0/fulladder_0/addsub_one_0[2]/xor3_1/a_63_n41# datapath_0/addsub_0/fulladder_0/addsub_one_0[2]/xor3_1/abar datapath_0/addsub_0/fulladder_0/addsub_one_0[2]/T_xor_b GND nfet w=4 l=5
+  ad=0 pd=0 as=0 ps=0
M2842 datapath_0/addsub_0/fulladder_0/addsub_one_0[2]/xor3_1/a_7_n16# datapath_0/addsub_0/fulladder_0/addsub_one_0[2]/xor3_1/bbar datapath_0/addsub_0/fulladder_0/addsub_one_0[2]/T_xor_b Vdd pfet w=10 l=5
+  ad=0 pd=0 as=130 ps=46
M2843 datapath_0/addsub_0/fulladder_0/addsub_one_0[2]/T_xor_b datapath_0/addsub_0/fulladder_0/addsub_one_0[2]/xor3_1/abar datapath_0/addsub_0/fulladder_0/addsub_one_0[2]/xor3_1/a_7_n16# Vdd pfet w=10 l=5
+  ad=0 pd=0 as=0 ps=0
M2844 datapath_0/addsub_0/fulladder_0/addsub_one_0[2]/xor3_1/a_7_n41# datapath_0/rx2 GND GND nfet w=4 l=5
+  ad=0 pd=0 as=0 ps=0
M2845 datapath_0/addsub_0/fulladder_0/addsub_one_0[2]/xor3_1/a_7_n16# datapath_0/rx2 Vdd Vdd pfet w=5 l=5
+  ad=0 pd=0 as=0 ps=0
M2846 datapath_0/addsub_0/fulladder_0/addsub_one_0[2]/nand2_2/a_7_10# datapath_0/addsub_0/fulladder_0/addsub_one_0[2]/cin GND GND nfet w=6 l=2
+  ad=42 pd=26 as=0 ps=0
M2847 datapath_0/addsub_0/fulladder_0/addsub_one_0[2]/nand2_3/B datapath_0/addsub_0/fulladder_0/addsub_one_0[2]/cin Vdd Vdd pfet w=12 l=2
+  ad=84 pd=38 as=0 ps=0
M2848 datapath_0/addsub_0/fulladder_0/addsub_one_0[2]/nand2_3/B datapath_0/addsub_0/fulladder_0/addsub_one_0[2]/T_xor_b datapath_0/addsub_0/fulladder_0/addsub_one_0[2]/nand2_2/a_7_10# GND nfet w=6 l=2
+  ad=36 pd=24 as=0 ps=0
M2849 Vdd datapath_0/addsub_0/fulladder_0/addsub_one_0[2]/T_xor_b datapath_0/addsub_0/fulladder_0/addsub_one_0[2]/nand2_3/B Vdd pfet w=12 l=2
+  ad=0 pd=0 as=0 ps=0
M2850 datapath_0/addsub_0/fulladder_0/addsub_one_0[2]/nand2_3/a_7_10# datapath_0/addsub_0/fulladder_0/addsub_one_0[2]/nand2_3/A GND GND nfet w=6 l=2
+  ad=42 pd=26 as=0 ps=0
M2851 datapath_0/addsub_0/fulladder_0/addsub_one_0[3]/cin datapath_0/addsub_0/fulladder_0/addsub_one_0[2]/nand2_3/A Vdd Vdd pfet w=12 l=2
+  ad=84 pd=38 as=0 ps=0
M2852 datapath_0/addsub_0/fulladder_0/addsub_one_0[3]/cin datapath_0/addsub_0/fulladder_0/addsub_one_0[2]/nand2_3/B datapath_0/addsub_0/fulladder_0/addsub_one_0[2]/nand2_3/a_7_10# GND nfet w=6 l=2
+  ad=36 pd=24 as=0 ps=0
M2853 Vdd datapath_0/addsub_0/fulladder_0/addsub_one_0[2]/nand2_3/B datapath_0/addsub_0/fulladder_0/addsub_one_0[3]/cin Vdd pfet w=12 l=2
+  ad=0 pd=0 as=0 ps=0
M2854 datapath_0/addsub_0/fulladder_0/addsub_one_0[2]/nand2_4/a_7_10# datapath_0/rx2 GND GND nfet w=6 l=2
+  ad=42 pd=26 as=0 ps=0
M2855 datapath_0/addsub_0/fulladder_0/addsub_one_0[2]/nand2_3/A datapath_0/rx2 Vdd Vdd pfet w=12 l=2
+  ad=84 pd=38 as=0 ps=0
M2856 datapath_0/addsub_0/fulladder_0/addsub_one_0[2]/nand2_3/A datapath_0/addsub_0/xor3_0[2]/out datapath_0/addsub_0/fulladder_0/addsub_one_0[2]/nand2_4/a_7_10# GND nfet w=6 l=2
+  ad=36 pd=24 as=0 ps=0
M2857 Vdd datapath_0/addsub_0/xor3_0[2]/out datapath_0/addsub_0/fulladder_0/addsub_one_0[2]/nand2_3/A Vdd pfet w=12 l=2
+  ad=0 pd=0 as=0 ps=0
M2858 datapath_0/addsub_0/fulladder_0/addsub_one_0[3]/xor3_0/abar datapath_0/addsub_0/fulladder_0/addsub_one_0[3]/cin GND GND nfet w=5 l=2
+  ad=30 pd=22 as=0 ps=0
M2859 datapath_0/addsub_0/fulladder_0/addsub_one_0[3]/xor3_0/abar datapath_0/addsub_0/fulladder_0/addsub_one_0[3]/cin Vdd Vdd pfet w=10 l=2
+  ad=60 pd=32 as=0 ps=0
M2860 datapath_0/addsub_0/fulladder_0/addsub_one_0[3]/xor3_0/bbar datapath_0/addsub_0/fulladder_0/addsub_one_0[3]/T_xor_b GND GND nfet w=5 l=2
+  ad=30 pd=22 as=0 ps=0
M2861 datapath_0/addsub_0/fulladder_0/addsub_one_0[3]/xor3_0/bbar datapath_0/addsub_0/fulladder_0/addsub_one_0[3]/T_xor_b Vdd Vdd pfet w=10 l=2
+  ad=60 pd=32 as=0 ps=0
M2862 datapath_0/latch_2/in3 datapath_0/addsub_0/fulladder_0/addsub_one_0[3]/T_xor_b datapath_0/addsub_0/fulladder_0/addsub_one_0[3]/xor3_0/a_7_n41# GND nfet w=4 l=5
+  ad=121 pd=68 as=68 ps=42
M2863 GND datapath_0/addsub_0/fulladder_0/addsub_one_0[3]/xor3_0/bbar datapath_0/addsub_0/fulladder_0/addsub_one_0[3]/xor3_0/a_63_n41# GND nfet w=4 l=5
+  ad=0 pd=0 as=52 ps=34
M2864 Vdd datapath_0/addsub_0/fulladder_0/addsub_one_0[3]/T_xor_b datapath_0/addsub_0/fulladder_0/addsub_one_0[3]/xor3_0/a_7_n16# Vdd pfet w=5 l=5
+  ad=0 pd=0 as=285 ps=124
M2865 datapath_0/addsub_0/fulladder_0/addsub_one_0[3]/xor3_0/a_63_n41# datapath_0/addsub_0/fulladder_0/addsub_one_0[3]/xor3_0/abar datapath_0/latch_2/in3 GND nfet w=4 l=5
+  ad=0 pd=0 as=0 ps=0
M2866 datapath_0/addsub_0/fulladder_0/addsub_one_0[3]/xor3_0/a_7_n16# datapath_0/addsub_0/fulladder_0/addsub_one_0[3]/xor3_0/bbar datapath_0/latch_2/in3 Vdd pfet w=10 l=5
+  ad=0 pd=0 as=130 ps=46
M2867 datapath_0/latch_2/in3 datapath_0/addsub_0/fulladder_0/addsub_one_0[3]/xor3_0/abar datapath_0/addsub_0/fulladder_0/addsub_one_0[3]/xor3_0/a_7_n16# Vdd pfet w=10 l=5
+  ad=0 pd=0 as=0 ps=0
M2868 datapath_0/addsub_0/fulladder_0/addsub_one_0[3]/xor3_0/a_7_n41# datapath_0/addsub_0/fulladder_0/addsub_one_0[3]/cin GND GND nfet w=4 l=5
+  ad=0 pd=0 as=0 ps=0
M2869 datapath_0/addsub_0/fulladder_0/addsub_one_0[3]/xor3_0/a_7_n16# datapath_0/addsub_0/fulladder_0/addsub_one_0[3]/cin Vdd Vdd pfet w=5 l=5
+  ad=0 pd=0 as=0 ps=0
M2870 datapath_0/addsub_0/fulladder_0/addsub_one_0[3]/xor3_1/abar datapath_0/rx3 GND GND nfet w=5 l=2
+  ad=30 pd=22 as=0 ps=0
M2871 datapath_0/addsub_0/fulladder_0/addsub_one_0[3]/xor3_1/abar datapath_0/rx3 Vdd Vdd pfet w=10 l=2
+  ad=60 pd=32 as=0 ps=0
M2872 datapath_0/addsub_0/fulladder_0/addsub_one_0[3]/xor3_1/bbar datapath_0/addsub_0/xor3_0[3]/out GND GND nfet w=5 l=2
+  ad=30 pd=22 as=0 ps=0
M2873 datapath_0/addsub_0/fulladder_0/addsub_one_0[3]/xor3_1/bbar datapath_0/addsub_0/xor3_0[3]/out Vdd Vdd pfet w=10 l=2
+  ad=60 pd=32 as=0 ps=0
M2874 datapath_0/addsub_0/fulladder_0/addsub_one_0[3]/T_xor_b datapath_0/addsub_0/xor3_0[3]/out datapath_0/addsub_0/fulladder_0/addsub_one_0[3]/xor3_1/a_7_n41# GND nfet w=4 l=5
+  ad=121 pd=68 as=68 ps=42
M2875 GND datapath_0/addsub_0/fulladder_0/addsub_one_0[3]/xor3_1/bbar datapath_0/addsub_0/fulladder_0/addsub_one_0[3]/xor3_1/a_63_n41# GND nfet w=4 l=5
+  ad=0 pd=0 as=52 ps=34
M2876 Vdd datapath_0/addsub_0/xor3_0[3]/out datapath_0/addsub_0/fulladder_0/addsub_one_0[3]/xor3_1/a_7_n16# Vdd pfet w=5 l=5
+  ad=0 pd=0 as=285 ps=124
M2877 datapath_0/addsub_0/fulladder_0/addsub_one_0[3]/xor3_1/a_63_n41# datapath_0/addsub_0/fulladder_0/addsub_one_0[3]/xor3_1/abar datapath_0/addsub_0/fulladder_0/addsub_one_0[3]/T_xor_b GND nfet w=4 l=5
+  ad=0 pd=0 as=0 ps=0
M2878 datapath_0/addsub_0/fulladder_0/addsub_one_0[3]/xor3_1/a_7_n16# datapath_0/addsub_0/fulladder_0/addsub_one_0[3]/xor3_1/bbar datapath_0/addsub_0/fulladder_0/addsub_one_0[3]/T_xor_b Vdd pfet w=10 l=5
+  ad=0 pd=0 as=130 ps=46
M2879 datapath_0/addsub_0/fulladder_0/addsub_one_0[3]/T_xor_b datapath_0/addsub_0/fulladder_0/addsub_one_0[3]/xor3_1/abar datapath_0/addsub_0/fulladder_0/addsub_one_0[3]/xor3_1/a_7_n16# Vdd pfet w=10 l=5
+  ad=0 pd=0 as=0 ps=0
M2880 datapath_0/addsub_0/fulladder_0/addsub_one_0[3]/xor3_1/a_7_n41# datapath_0/rx3 GND GND nfet w=4 l=5
+  ad=0 pd=0 as=0 ps=0
M2881 datapath_0/addsub_0/fulladder_0/addsub_one_0[3]/xor3_1/a_7_n16# datapath_0/rx3 Vdd Vdd pfet w=5 l=5
+  ad=0 pd=0 as=0 ps=0
M2882 datapath_0/addsub_0/fulladder_0/addsub_one_0[3]/nand2_2/a_7_10# datapath_0/addsub_0/fulladder_0/addsub_one_0[3]/cin GND GND nfet w=6 l=2
+  ad=42 pd=26 as=0 ps=0
M2883 datapath_0/addsub_0/fulladder_0/addsub_one_0[3]/nand2_3/B datapath_0/addsub_0/fulladder_0/addsub_one_0[3]/cin Vdd Vdd pfet w=12 l=2
+  ad=84 pd=38 as=0 ps=0
M2884 datapath_0/addsub_0/fulladder_0/addsub_one_0[3]/nand2_3/B datapath_0/addsub_0/fulladder_0/addsub_one_0[3]/T_xor_b datapath_0/addsub_0/fulladder_0/addsub_one_0[3]/nand2_2/a_7_10# GND nfet w=6 l=2
+  ad=36 pd=24 as=0 ps=0
M2885 Vdd datapath_0/addsub_0/fulladder_0/addsub_one_0[3]/T_xor_b datapath_0/addsub_0/fulladder_0/addsub_one_0[3]/nand2_3/B Vdd pfet w=12 l=2
+  ad=0 pd=0 as=0 ps=0
M2886 datapath_0/addsub_0/fulladder_0/addsub_one_0[3]/nand2_3/a_7_10# datapath_0/addsub_0/fulladder_0/addsub_one_0[3]/nand2_3/A GND GND nfet w=6 l=2
+  ad=42 pd=26 as=0 ps=0
M2887 datapath_0/addsub_0/fulladder_0/addsub_one_0[4]/cin datapath_0/addsub_0/fulladder_0/addsub_one_0[3]/nand2_3/A Vdd Vdd pfet w=12 l=2
+  ad=84 pd=38 as=0 ps=0
M2888 datapath_0/addsub_0/fulladder_0/addsub_one_0[4]/cin datapath_0/addsub_0/fulladder_0/addsub_one_0[3]/nand2_3/B datapath_0/addsub_0/fulladder_0/addsub_one_0[3]/nand2_3/a_7_10# GND nfet w=6 l=2
+  ad=36 pd=24 as=0 ps=0
M2889 Vdd datapath_0/addsub_0/fulladder_0/addsub_one_0[3]/nand2_3/B datapath_0/addsub_0/fulladder_0/addsub_one_0[4]/cin Vdd pfet w=12 l=2
+  ad=0 pd=0 as=0 ps=0
M2890 datapath_0/addsub_0/fulladder_0/addsub_one_0[3]/nand2_4/a_7_10# datapath_0/rx3 GND GND nfet w=6 l=2
+  ad=42 pd=26 as=0 ps=0
M2891 datapath_0/addsub_0/fulladder_0/addsub_one_0[3]/nand2_3/A datapath_0/rx3 Vdd Vdd pfet w=12 l=2
+  ad=84 pd=38 as=0 ps=0
M2892 datapath_0/addsub_0/fulladder_0/addsub_one_0[3]/nand2_3/A datapath_0/addsub_0/xor3_0[3]/out datapath_0/addsub_0/fulladder_0/addsub_one_0[3]/nand2_4/a_7_10# GND nfet w=6 l=2
+  ad=36 pd=24 as=0 ps=0
M2893 Vdd datapath_0/addsub_0/xor3_0[3]/out datapath_0/addsub_0/fulladder_0/addsub_one_0[3]/nand2_3/A Vdd pfet w=12 l=2
+  ad=0 pd=0 as=0 ps=0
M2894 datapath_0/addsub_0/fulladder_0/addsub_one_0[4]/xor3_0/abar datapath_0/addsub_0/fulladder_0/addsub_one_0[4]/cin GND GND nfet w=5 l=2
+  ad=30 pd=22 as=0 ps=0
M2895 datapath_0/addsub_0/fulladder_0/addsub_one_0[4]/xor3_0/abar datapath_0/addsub_0/fulladder_0/addsub_one_0[4]/cin Vdd Vdd pfet w=10 l=2
+  ad=60 pd=32 as=0 ps=0
M2896 datapath_0/addsub_0/fulladder_0/addsub_one_0[4]/xor3_0/bbar datapath_0/addsub_0/fulladder_0/addsub_one_0[4]/T_xor_b GND GND nfet w=5 l=2
+  ad=30 pd=22 as=0 ps=0
M2897 datapath_0/addsub_0/fulladder_0/addsub_one_0[4]/xor3_0/bbar datapath_0/addsub_0/fulladder_0/addsub_one_0[4]/T_xor_b Vdd Vdd pfet w=10 l=2
+  ad=60 pd=32 as=0 ps=0
M2898 datapath_0/latch_2/in4 datapath_0/addsub_0/fulladder_0/addsub_one_0[4]/T_xor_b datapath_0/addsub_0/fulladder_0/addsub_one_0[4]/xor3_0/a_7_n41# GND nfet w=4 l=5
+  ad=121 pd=68 as=68 ps=42
M2899 GND datapath_0/addsub_0/fulladder_0/addsub_one_0[4]/xor3_0/bbar datapath_0/addsub_0/fulladder_0/addsub_one_0[4]/xor3_0/a_63_n41# GND nfet w=4 l=5
+  ad=0 pd=0 as=52 ps=34
M2900 Vdd datapath_0/addsub_0/fulladder_0/addsub_one_0[4]/T_xor_b datapath_0/addsub_0/fulladder_0/addsub_one_0[4]/xor3_0/a_7_n16# Vdd pfet w=5 l=5
+  ad=0 pd=0 as=285 ps=124
M2901 datapath_0/addsub_0/fulladder_0/addsub_one_0[4]/xor3_0/a_63_n41# datapath_0/addsub_0/fulladder_0/addsub_one_0[4]/xor3_0/abar datapath_0/latch_2/in4 GND nfet w=4 l=5
+  ad=0 pd=0 as=0 ps=0
M2902 datapath_0/addsub_0/fulladder_0/addsub_one_0[4]/xor3_0/a_7_n16# datapath_0/addsub_0/fulladder_0/addsub_one_0[4]/xor3_0/bbar datapath_0/latch_2/in4 Vdd pfet w=10 l=5
+  ad=0 pd=0 as=130 ps=46
M2903 datapath_0/latch_2/in4 datapath_0/addsub_0/fulladder_0/addsub_one_0[4]/xor3_0/abar datapath_0/addsub_0/fulladder_0/addsub_one_0[4]/xor3_0/a_7_n16# Vdd pfet w=10 l=5
+  ad=0 pd=0 as=0 ps=0
M2904 datapath_0/addsub_0/fulladder_0/addsub_one_0[4]/xor3_0/a_7_n41# datapath_0/addsub_0/fulladder_0/addsub_one_0[4]/cin GND GND nfet w=4 l=5
+  ad=0 pd=0 as=0 ps=0
M2905 datapath_0/addsub_0/fulladder_0/addsub_one_0[4]/xor3_0/a_7_n16# datapath_0/addsub_0/fulladder_0/addsub_one_0[4]/cin Vdd Vdd pfet w=5 l=5
+  ad=0 pd=0 as=0 ps=0
M2906 datapath_0/addsub_0/fulladder_0/addsub_one_0[4]/xor3_1/abar datapath_0/rx4 GND GND nfet w=5 l=2
+  ad=30 pd=22 as=0 ps=0
M2907 datapath_0/addsub_0/fulladder_0/addsub_one_0[4]/xor3_1/abar datapath_0/rx4 Vdd Vdd pfet w=10 l=2
+  ad=60 pd=32 as=0 ps=0
M2908 datapath_0/addsub_0/fulladder_0/addsub_one_0[4]/xor3_1/bbar datapath_0/addsub_0/xor3_0[4]/out GND GND nfet w=5 l=2
+  ad=30 pd=22 as=0 ps=0
M2909 datapath_0/addsub_0/fulladder_0/addsub_one_0[4]/xor3_1/bbar datapath_0/addsub_0/xor3_0[4]/out Vdd Vdd pfet w=10 l=2
+  ad=60 pd=32 as=0 ps=0
M2910 datapath_0/addsub_0/fulladder_0/addsub_one_0[4]/T_xor_b datapath_0/addsub_0/xor3_0[4]/out datapath_0/addsub_0/fulladder_0/addsub_one_0[4]/xor3_1/a_7_n41# GND nfet w=4 l=5
+  ad=121 pd=68 as=68 ps=42
M2911 GND datapath_0/addsub_0/fulladder_0/addsub_one_0[4]/xor3_1/bbar datapath_0/addsub_0/fulladder_0/addsub_one_0[4]/xor3_1/a_63_n41# GND nfet w=4 l=5
+  ad=0 pd=0 as=52 ps=34
M2912 Vdd datapath_0/addsub_0/xor3_0[4]/out datapath_0/addsub_0/fulladder_0/addsub_one_0[4]/xor3_1/a_7_n16# Vdd pfet w=5 l=5
+  ad=0 pd=0 as=285 ps=124
M2913 datapath_0/addsub_0/fulladder_0/addsub_one_0[4]/xor3_1/a_63_n41# datapath_0/addsub_0/fulladder_0/addsub_one_0[4]/xor3_1/abar datapath_0/addsub_0/fulladder_0/addsub_one_0[4]/T_xor_b GND nfet w=4 l=5
+  ad=0 pd=0 as=0 ps=0
M2914 datapath_0/addsub_0/fulladder_0/addsub_one_0[4]/xor3_1/a_7_n16# datapath_0/addsub_0/fulladder_0/addsub_one_0[4]/xor3_1/bbar datapath_0/addsub_0/fulladder_0/addsub_one_0[4]/T_xor_b Vdd pfet w=10 l=5
+  ad=0 pd=0 as=130 ps=46
M2915 datapath_0/addsub_0/fulladder_0/addsub_one_0[4]/T_xor_b datapath_0/addsub_0/fulladder_0/addsub_one_0[4]/xor3_1/abar datapath_0/addsub_0/fulladder_0/addsub_one_0[4]/xor3_1/a_7_n16# Vdd pfet w=10 l=5
+  ad=0 pd=0 as=0 ps=0
M2916 datapath_0/addsub_0/fulladder_0/addsub_one_0[4]/xor3_1/a_7_n41# datapath_0/rx4 GND GND nfet w=4 l=5
+  ad=0 pd=0 as=0 ps=0
M2917 datapath_0/addsub_0/fulladder_0/addsub_one_0[4]/xor3_1/a_7_n16# datapath_0/rx4 Vdd Vdd pfet w=5 l=5
+  ad=0 pd=0 as=0 ps=0
M2918 datapath_0/addsub_0/fulladder_0/addsub_one_0[4]/nand2_2/a_7_10# datapath_0/addsub_0/fulladder_0/addsub_one_0[4]/cin GND GND nfet w=6 l=2
+  ad=42 pd=26 as=0 ps=0
M2919 datapath_0/addsub_0/fulladder_0/addsub_one_0[4]/nand2_3/B datapath_0/addsub_0/fulladder_0/addsub_one_0[4]/cin Vdd Vdd pfet w=12 l=2
+  ad=84 pd=38 as=0 ps=0
M2920 datapath_0/addsub_0/fulladder_0/addsub_one_0[4]/nand2_3/B datapath_0/addsub_0/fulladder_0/addsub_one_0[4]/T_xor_b datapath_0/addsub_0/fulladder_0/addsub_one_0[4]/nand2_2/a_7_10# GND nfet w=6 l=2
+  ad=36 pd=24 as=0 ps=0
M2921 Vdd datapath_0/addsub_0/fulladder_0/addsub_one_0[4]/T_xor_b datapath_0/addsub_0/fulladder_0/addsub_one_0[4]/nand2_3/B Vdd pfet w=12 l=2
+  ad=0 pd=0 as=0 ps=0
M2922 datapath_0/addsub_0/fulladder_0/addsub_one_0[4]/nand2_3/a_7_10# datapath_0/addsub_0/fulladder_0/addsub_one_0[4]/nand2_3/A GND GND nfet w=6 l=2
+  ad=42 pd=26 as=0 ps=0
M2923 datapath_0/addsub_0/fulladder_0/addsub_one_0[5]/cin datapath_0/addsub_0/fulladder_0/addsub_one_0[4]/nand2_3/A Vdd Vdd pfet w=12 l=2
+  ad=84 pd=38 as=0 ps=0
M2924 datapath_0/addsub_0/fulladder_0/addsub_one_0[5]/cin datapath_0/addsub_0/fulladder_0/addsub_one_0[4]/nand2_3/B datapath_0/addsub_0/fulladder_0/addsub_one_0[4]/nand2_3/a_7_10# GND nfet w=6 l=2
+  ad=36 pd=24 as=0 ps=0
M2925 Vdd datapath_0/addsub_0/fulladder_0/addsub_one_0[4]/nand2_3/B datapath_0/addsub_0/fulladder_0/addsub_one_0[5]/cin Vdd pfet w=12 l=2
+  ad=0 pd=0 as=0 ps=0
M2926 datapath_0/addsub_0/fulladder_0/addsub_one_0[4]/nand2_4/a_7_10# datapath_0/rx4 GND GND nfet w=6 l=2
+  ad=42 pd=26 as=0 ps=0
M2927 datapath_0/addsub_0/fulladder_0/addsub_one_0[4]/nand2_3/A datapath_0/rx4 Vdd Vdd pfet w=12 l=2
+  ad=84 pd=38 as=0 ps=0
M2928 datapath_0/addsub_0/fulladder_0/addsub_one_0[4]/nand2_3/A datapath_0/addsub_0/xor3_0[4]/out datapath_0/addsub_0/fulladder_0/addsub_one_0[4]/nand2_4/a_7_10# GND nfet w=6 l=2
+  ad=36 pd=24 as=0 ps=0
M2929 Vdd datapath_0/addsub_0/xor3_0[4]/out datapath_0/addsub_0/fulladder_0/addsub_one_0[4]/nand2_3/A Vdd pfet w=12 l=2
+  ad=0 pd=0 as=0 ps=0
M2930 datapath_0/addsub_0/fulladder_0/addsub_one_0[5]/xor3_0/abar datapath_0/addsub_0/fulladder_0/addsub_one_0[5]/cin GND GND nfet w=5 l=2
+  ad=30 pd=22 as=0 ps=0
M2931 datapath_0/addsub_0/fulladder_0/addsub_one_0[5]/xor3_0/abar datapath_0/addsub_0/fulladder_0/addsub_one_0[5]/cin Vdd Vdd pfet w=10 l=2
+  ad=60 pd=32 as=0 ps=0
M2932 datapath_0/addsub_0/fulladder_0/addsub_one_0[5]/xor3_0/bbar datapath_0/addsub_0/fulladder_0/addsub_one_0[5]/T_xor_b GND GND nfet w=5 l=2
+  ad=30 pd=22 as=0 ps=0
M2933 datapath_0/addsub_0/fulladder_0/addsub_one_0[5]/xor3_0/bbar datapath_0/addsub_0/fulladder_0/addsub_one_0[5]/T_xor_b Vdd Vdd pfet w=10 l=2
+  ad=60 pd=32 as=0 ps=0
M2934 datapath_0/latch_2/in5 datapath_0/addsub_0/fulladder_0/addsub_one_0[5]/T_xor_b datapath_0/addsub_0/fulladder_0/addsub_one_0[5]/xor3_0/a_7_n41# GND nfet w=4 l=5
+  ad=121 pd=68 as=68 ps=42
M2935 GND datapath_0/addsub_0/fulladder_0/addsub_one_0[5]/xor3_0/bbar datapath_0/addsub_0/fulladder_0/addsub_one_0[5]/xor3_0/a_63_n41# GND nfet w=4 l=5
+  ad=0 pd=0 as=52 ps=34
M2936 Vdd datapath_0/addsub_0/fulladder_0/addsub_one_0[5]/T_xor_b datapath_0/addsub_0/fulladder_0/addsub_one_0[5]/xor3_0/a_7_n16# Vdd pfet w=5 l=5
+  ad=0 pd=0 as=285 ps=124
M2937 datapath_0/addsub_0/fulladder_0/addsub_one_0[5]/xor3_0/a_63_n41# datapath_0/addsub_0/fulladder_0/addsub_one_0[5]/xor3_0/abar datapath_0/latch_2/in5 GND nfet w=4 l=5
+  ad=0 pd=0 as=0 ps=0
M2938 datapath_0/addsub_0/fulladder_0/addsub_one_0[5]/xor3_0/a_7_n16# datapath_0/addsub_0/fulladder_0/addsub_one_0[5]/xor3_0/bbar datapath_0/latch_2/in5 Vdd pfet w=10 l=5
+  ad=0 pd=0 as=130 ps=46
M2939 datapath_0/latch_2/in5 datapath_0/addsub_0/fulladder_0/addsub_one_0[5]/xor3_0/abar datapath_0/addsub_0/fulladder_0/addsub_one_0[5]/xor3_0/a_7_n16# Vdd pfet w=10 l=5
+  ad=0 pd=0 as=0 ps=0
M2940 datapath_0/addsub_0/fulladder_0/addsub_one_0[5]/xor3_0/a_7_n41# datapath_0/addsub_0/fulladder_0/addsub_one_0[5]/cin GND GND nfet w=4 l=5
+  ad=0 pd=0 as=0 ps=0
M2941 datapath_0/addsub_0/fulladder_0/addsub_one_0[5]/xor3_0/a_7_n16# datapath_0/addsub_0/fulladder_0/addsub_one_0[5]/cin Vdd Vdd pfet w=5 l=5
+  ad=0 pd=0 as=0 ps=0
M2942 datapath_0/addsub_0/fulladder_0/addsub_one_0[5]/xor3_1/abar datapath_0/rx5 GND GND nfet w=5 l=2
+  ad=30 pd=22 as=0 ps=0
M2943 datapath_0/addsub_0/fulladder_0/addsub_one_0[5]/xor3_1/abar datapath_0/rx5 Vdd Vdd pfet w=10 l=2
+  ad=60 pd=32 as=0 ps=0
M2944 datapath_0/addsub_0/fulladder_0/addsub_one_0[5]/xor3_1/bbar datapath_0/addsub_0/xor3_0[5]/out GND GND nfet w=5 l=2
+  ad=30 pd=22 as=0 ps=0
M2945 datapath_0/addsub_0/fulladder_0/addsub_one_0[5]/xor3_1/bbar datapath_0/addsub_0/xor3_0[5]/out Vdd Vdd pfet w=10 l=2
+  ad=60 pd=32 as=0 ps=0
M2946 datapath_0/addsub_0/fulladder_0/addsub_one_0[5]/T_xor_b datapath_0/addsub_0/xor3_0[5]/out datapath_0/addsub_0/fulladder_0/addsub_one_0[5]/xor3_1/a_7_n41# GND nfet w=4 l=5
+  ad=121 pd=68 as=68 ps=42
M2947 GND datapath_0/addsub_0/fulladder_0/addsub_one_0[5]/xor3_1/bbar datapath_0/addsub_0/fulladder_0/addsub_one_0[5]/xor3_1/a_63_n41# GND nfet w=4 l=5
+  ad=0 pd=0 as=52 ps=34
M2948 Vdd datapath_0/addsub_0/xor3_0[5]/out datapath_0/addsub_0/fulladder_0/addsub_one_0[5]/xor3_1/a_7_n16# Vdd pfet w=5 l=5
+  ad=0 pd=0 as=285 ps=124
M2949 datapath_0/addsub_0/fulladder_0/addsub_one_0[5]/xor3_1/a_63_n41# datapath_0/addsub_0/fulladder_0/addsub_one_0[5]/xor3_1/abar datapath_0/addsub_0/fulladder_0/addsub_one_0[5]/T_xor_b GND nfet w=4 l=5
+  ad=0 pd=0 as=0 ps=0
M2950 datapath_0/addsub_0/fulladder_0/addsub_one_0[5]/xor3_1/a_7_n16# datapath_0/addsub_0/fulladder_0/addsub_one_0[5]/xor3_1/bbar datapath_0/addsub_0/fulladder_0/addsub_one_0[5]/T_xor_b Vdd pfet w=10 l=5
+  ad=0 pd=0 as=130 ps=46
M2951 datapath_0/addsub_0/fulladder_0/addsub_one_0[5]/T_xor_b datapath_0/addsub_0/fulladder_0/addsub_one_0[5]/xor3_1/abar datapath_0/addsub_0/fulladder_0/addsub_one_0[5]/xor3_1/a_7_n16# Vdd pfet w=10 l=5
+  ad=0 pd=0 as=0 ps=0
M2952 datapath_0/addsub_0/fulladder_0/addsub_one_0[5]/xor3_1/a_7_n41# datapath_0/rx5 GND GND nfet w=4 l=5
+  ad=0 pd=0 as=0 ps=0
M2953 datapath_0/addsub_0/fulladder_0/addsub_one_0[5]/xor3_1/a_7_n16# datapath_0/rx5 Vdd Vdd pfet w=5 l=5
+  ad=0 pd=0 as=0 ps=0
M2954 datapath_0/addsub_0/fulladder_0/addsub_one_0[5]/nand2_2/a_7_10# datapath_0/addsub_0/fulladder_0/addsub_one_0[5]/cin GND GND nfet w=6 l=2
+  ad=42 pd=26 as=0 ps=0
M2955 datapath_0/addsub_0/fulladder_0/addsub_one_0[5]/nand2_3/B datapath_0/addsub_0/fulladder_0/addsub_one_0[5]/cin Vdd Vdd pfet w=12 l=2
+  ad=84 pd=38 as=0 ps=0
M2956 datapath_0/addsub_0/fulladder_0/addsub_one_0[5]/nand2_3/B datapath_0/addsub_0/fulladder_0/addsub_one_0[5]/T_xor_b datapath_0/addsub_0/fulladder_0/addsub_one_0[5]/nand2_2/a_7_10# GND nfet w=6 l=2
+  ad=36 pd=24 as=0 ps=0
M2957 Vdd datapath_0/addsub_0/fulladder_0/addsub_one_0[5]/T_xor_b datapath_0/addsub_0/fulladder_0/addsub_one_0[5]/nand2_3/B Vdd pfet w=12 l=2
+  ad=0 pd=0 as=0 ps=0
M2958 datapath_0/addsub_0/fulladder_0/addsub_one_0[5]/nand2_3/a_7_10# datapath_0/addsub_0/fulladder_0/addsub_one_0[5]/nand2_3/A GND GND nfet w=6 l=2
+  ad=42 pd=26 as=0 ps=0
M2959 datapath_0/addsub_0/fulladder_0/addsub_one_0[6]/cin datapath_0/addsub_0/fulladder_0/addsub_one_0[5]/nand2_3/A Vdd Vdd pfet w=12 l=2
+  ad=84 pd=38 as=0 ps=0
M2960 datapath_0/addsub_0/fulladder_0/addsub_one_0[6]/cin datapath_0/addsub_0/fulladder_0/addsub_one_0[5]/nand2_3/B datapath_0/addsub_0/fulladder_0/addsub_one_0[5]/nand2_3/a_7_10# GND nfet w=6 l=2
+  ad=36 pd=24 as=0 ps=0
M2961 Vdd datapath_0/addsub_0/fulladder_0/addsub_one_0[5]/nand2_3/B datapath_0/addsub_0/fulladder_0/addsub_one_0[6]/cin Vdd pfet w=12 l=2
+  ad=0 pd=0 as=0 ps=0
M2962 datapath_0/addsub_0/fulladder_0/addsub_one_0[5]/nand2_4/a_7_10# datapath_0/rx5 GND GND nfet w=6 l=2
+  ad=42 pd=26 as=0 ps=0
M2963 datapath_0/addsub_0/fulladder_0/addsub_one_0[5]/nand2_3/A datapath_0/rx5 Vdd Vdd pfet w=12 l=2
+  ad=84 pd=38 as=0 ps=0
M2964 datapath_0/addsub_0/fulladder_0/addsub_one_0[5]/nand2_3/A datapath_0/addsub_0/xor3_0[5]/out datapath_0/addsub_0/fulladder_0/addsub_one_0[5]/nand2_4/a_7_10# GND nfet w=6 l=2
+  ad=36 pd=24 as=0 ps=0
M2965 Vdd datapath_0/addsub_0/xor3_0[5]/out datapath_0/addsub_0/fulladder_0/addsub_one_0[5]/nand2_3/A Vdd pfet w=12 l=2
+  ad=0 pd=0 as=0 ps=0
M2966 datapath_0/addsub_0/fulladder_0/addsub_one_0[6]/xor3_0/abar datapath_0/addsub_0/fulladder_0/addsub_one_0[6]/cin GND GND nfet w=5 l=2
+  ad=30 pd=22 as=0 ps=0
M2967 datapath_0/addsub_0/fulladder_0/addsub_one_0[6]/xor3_0/abar datapath_0/addsub_0/fulladder_0/addsub_one_0[6]/cin Vdd Vdd pfet w=10 l=2
+  ad=60 pd=32 as=0 ps=0
M2968 datapath_0/addsub_0/fulladder_0/addsub_one_0[6]/xor3_0/bbar datapath_0/addsub_0/fulladder_0/addsub_one_0[6]/T_xor_b GND GND nfet w=5 l=2
+  ad=30 pd=22 as=0 ps=0
M2969 datapath_0/addsub_0/fulladder_0/addsub_one_0[6]/xor3_0/bbar datapath_0/addsub_0/fulladder_0/addsub_one_0[6]/T_xor_b Vdd Vdd pfet w=10 l=2
+  ad=60 pd=32 as=0 ps=0
M2970 datapath_0/latch_2/in6 datapath_0/addsub_0/fulladder_0/addsub_one_0[6]/T_xor_b datapath_0/addsub_0/fulladder_0/addsub_one_0[6]/xor3_0/a_7_n41# GND nfet w=4 l=5
+  ad=121 pd=68 as=68 ps=42
M2971 GND datapath_0/addsub_0/fulladder_0/addsub_one_0[6]/xor3_0/bbar datapath_0/addsub_0/fulladder_0/addsub_one_0[6]/xor3_0/a_63_n41# GND nfet w=4 l=5
+  ad=0 pd=0 as=52 ps=34
M2972 Vdd datapath_0/addsub_0/fulladder_0/addsub_one_0[6]/T_xor_b datapath_0/addsub_0/fulladder_0/addsub_one_0[6]/xor3_0/a_7_n16# Vdd pfet w=5 l=5
+  ad=0 pd=0 as=285 ps=124
M2973 datapath_0/addsub_0/fulladder_0/addsub_one_0[6]/xor3_0/a_63_n41# datapath_0/addsub_0/fulladder_0/addsub_one_0[6]/xor3_0/abar datapath_0/latch_2/in6 GND nfet w=4 l=5
+  ad=0 pd=0 as=0 ps=0
M2974 datapath_0/addsub_0/fulladder_0/addsub_one_0[6]/xor3_0/a_7_n16# datapath_0/addsub_0/fulladder_0/addsub_one_0[6]/xor3_0/bbar datapath_0/latch_2/in6 Vdd pfet w=10 l=5
+  ad=0 pd=0 as=130 ps=46
M2975 datapath_0/latch_2/in6 datapath_0/addsub_0/fulladder_0/addsub_one_0[6]/xor3_0/abar datapath_0/addsub_0/fulladder_0/addsub_one_0[6]/xor3_0/a_7_n16# Vdd pfet w=10 l=5
+  ad=0 pd=0 as=0 ps=0
M2976 datapath_0/addsub_0/fulladder_0/addsub_one_0[6]/xor3_0/a_7_n41# datapath_0/addsub_0/fulladder_0/addsub_one_0[6]/cin GND GND nfet w=4 l=5
+  ad=0 pd=0 as=0 ps=0
M2977 datapath_0/addsub_0/fulladder_0/addsub_one_0[6]/xor3_0/a_7_n16# datapath_0/addsub_0/fulladder_0/addsub_one_0[6]/cin Vdd Vdd pfet w=5 l=5
+  ad=0 pd=0 as=0 ps=0
M2978 datapath_0/addsub_0/fulladder_0/addsub_one_0[6]/xor3_1/abar datapath_0/rx6 GND GND nfet w=5 l=2
+  ad=30 pd=22 as=0 ps=0
M2979 datapath_0/addsub_0/fulladder_0/addsub_one_0[6]/xor3_1/abar datapath_0/rx6 Vdd Vdd pfet w=10 l=2
+  ad=60 pd=32 as=0 ps=0
M2980 datapath_0/addsub_0/fulladder_0/addsub_one_0[6]/xor3_1/bbar datapath_0/addsub_0/xor3_0[6]/out GND GND nfet w=5 l=2
+  ad=30 pd=22 as=0 ps=0
M2981 datapath_0/addsub_0/fulladder_0/addsub_one_0[6]/xor3_1/bbar datapath_0/addsub_0/xor3_0[6]/out Vdd Vdd pfet w=10 l=2
+  ad=60 pd=32 as=0 ps=0
M2982 datapath_0/addsub_0/fulladder_0/addsub_one_0[6]/T_xor_b datapath_0/addsub_0/xor3_0[6]/out datapath_0/addsub_0/fulladder_0/addsub_one_0[6]/xor3_1/a_7_n41# GND nfet w=4 l=5
+  ad=121 pd=68 as=68 ps=42
M2983 GND datapath_0/addsub_0/fulladder_0/addsub_one_0[6]/xor3_1/bbar datapath_0/addsub_0/fulladder_0/addsub_one_0[6]/xor3_1/a_63_n41# GND nfet w=4 l=5
+  ad=0 pd=0 as=52 ps=34
M2984 Vdd datapath_0/addsub_0/xor3_0[6]/out datapath_0/addsub_0/fulladder_0/addsub_one_0[6]/xor3_1/a_7_n16# Vdd pfet w=5 l=5
+  ad=0 pd=0 as=285 ps=124
M2985 datapath_0/addsub_0/fulladder_0/addsub_one_0[6]/xor3_1/a_63_n41# datapath_0/addsub_0/fulladder_0/addsub_one_0[6]/xor3_1/abar datapath_0/addsub_0/fulladder_0/addsub_one_0[6]/T_xor_b GND nfet w=4 l=5
+  ad=0 pd=0 as=0 ps=0
M2986 datapath_0/addsub_0/fulladder_0/addsub_one_0[6]/xor3_1/a_7_n16# datapath_0/addsub_0/fulladder_0/addsub_one_0[6]/xor3_1/bbar datapath_0/addsub_0/fulladder_0/addsub_one_0[6]/T_xor_b Vdd pfet w=10 l=5
+  ad=0 pd=0 as=130 ps=46
M2987 datapath_0/addsub_0/fulladder_0/addsub_one_0[6]/T_xor_b datapath_0/addsub_0/fulladder_0/addsub_one_0[6]/xor3_1/abar datapath_0/addsub_0/fulladder_0/addsub_one_0[6]/xor3_1/a_7_n16# Vdd pfet w=10 l=5
+  ad=0 pd=0 as=0 ps=0
M2988 datapath_0/addsub_0/fulladder_0/addsub_one_0[6]/xor3_1/a_7_n41# datapath_0/rx6 GND GND nfet w=4 l=5
+  ad=0 pd=0 as=0 ps=0
M2989 datapath_0/addsub_0/fulladder_0/addsub_one_0[6]/xor3_1/a_7_n16# datapath_0/rx6 Vdd Vdd pfet w=5 l=5
+  ad=0 pd=0 as=0 ps=0
M2990 datapath_0/addsub_0/fulladder_0/addsub_one_0[6]/nand2_2/a_7_10# datapath_0/addsub_0/fulladder_0/addsub_one_0[6]/cin GND GND nfet w=6 l=2
+  ad=42 pd=26 as=0 ps=0
M2991 datapath_0/addsub_0/fulladder_0/addsub_one_0[6]/nand2_3/B datapath_0/addsub_0/fulladder_0/addsub_one_0[6]/cin Vdd Vdd pfet w=12 l=2
+  ad=84 pd=38 as=0 ps=0
M2992 datapath_0/addsub_0/fulladder_0/addsub_one_0[6]/nand2_3/B datapath_0/addsub_0/fulladder_0/addsub_one_0[6]/T_xor_b datapath_0/addsub_0/fulladder_0/addsub_one_0[6]/nand2_2/a_7_10# GND nfet w=6 l=2
+  ad=36 pd=24 as=0 ps=0
M2993 Vdd datapath_0/addsub_0/fulladder_0/addsub_one_0[6]/T_xor_b datapath_0/addsub_0/fulladder_0/addsub_one_0[6]/nand2_3/B Vdd pfet w=12 l=2
+  ad=0 pd=0 as=0 ps=0
M2994 datapath_0/addsub_0/fulladder_0/addsub_one_0[6]/nand2_3/a_7_10# datapath_0/addsub_0/fulladder_0/addsub_one_0[6]/nand2_3/A GND GND nfet w=6 l=2
+  ad=42 pd=26 as=0 ps=0
M2995 datapath_0/addsub_0/fulladder_0/addsub_one_0[7]/cin datapath_0/addsub_0/fulladder_0/addsub_one_0[6]/nand2_3/A Vdd Vdd pfet w=12 l=2
+  ad=84 pd=38 as=0 ps=0
M2996 datapath_0/addsub_0/fulladder_0/addsub_one_0[7]/cin datapath_0/addsub_0/fulladder_0/addsub_one_0[6]/nand2_3/B datapath_0/addsub_0/fulladder_0/addsub_one_0[6]/nand2_3/a_7_10# GND nfet w=6 l=2
+  ad=36 pd=24 as=0 ps=0
M2997 Vdd datapath_0/addsub_0/fulladder_0/addsub_one_0[6]/nand2_3/B datapath_0/addsub_0/fulladder_0/addsub_one_0[7]/cin Vdd pfet w=12 l=2
+  ad=0 pd=0 as=0 ps=0
M2998 datapath_0/addsub_0/fulladder_0/addsub_one_0[6]/nand2_4/a_7_10# datapath_0/rx6 GND GND nfet w=6 l=2
+  ad=42 pd=26 as=0 ps=0
M2999 datapath_0/addsub_0/fulladder_0/addsub_one_0[6]/nand2_3/A datapath_0/rx6 Vdd Vdd pfet w=12 l=2
+  ad=84 pd=38 as=0 ps=0
M3000 datapath_0/addsub_0/fulladder_0/addsub_one_0[6]/nand2_3/A datapath_0/addsub_0/xor3_0[6]/out datapath_0/addsub_0/fulladder_0/addsub_one_0[6]/nand2_4/a_7_10# GND nfet w=6 l=2
+  ad=36 pd=24 as=0 ps=0
M3001 Vdd datapath_0/addsub_0/xor3_0[6]/out datapath_0/addsub_0/fulladder_0/addsub_one_0[6]/nand2_3/A Vdd pfet w=12 l=2
+  ad=0 pd=0 as=0 ps=0
M3002 datapath_0/addsub_0/fulladder_0/addsub_one_0[7]/xor3_0/abar datapath_0/addsub_0/fulladder_0/addsub_one_0[7]/cin GND GND nfet w=5 l=2
+  ad=30 pd=22 as=0 ps=0
M3003 datapath_0/addsub_0/fulladder_0/addsub_one_0[7]/xor3_0/abar datapath_0/addsub_0/fulladder_0/addsub_one_0[7]/cin Vdd Vdd pfet w=10 l=2
+  ad=60 pd=32 as=0 ps=0
M3004 datapath_0/addsub_0/fulladder_0/addsub_one_0[7]/xor3_0/bbar datapath_0/addsub_0/fulladder_0/addsub_one_0[7]/T_xor_b GND GND nfet w=5 l=2
+  ad=30 pd=22 as=0 ps=0
M3005 datapath_0/addsub_0/fulladder_0/addsub_one_0[7]/xor3_0/bbar datapath_0/addsub_0/fulladder_0/addsub_one_0[7]/T_xor_b Vdd Vdd pfet w=10 l=2
+  ad=60 pd=32 as=0 ps=0
M3006 datapath_0/latch_2/in7 datapath_0/addsub_0/fulladder_0/addsub_one_0[7]/T_xor_b datapath_0/addsub_0/fulladder_0/addsub_one_0[7]/xor3_0/a_7_n41# GND nfet w=4 l=5
+  ad=121 pd=68 as=68 ps=42
M3007 GND datapath_0/addsub_0/fulladder_0/addsub_one_0[7]/xor3_0/bbar datapath_0/addsub_0/fulladder_0/addsub_one_0[7]/xor3_0/a_63_n41# GND nfet w=4 l=5
+  ad=0 pd=0 as=52 ps=34
M3008 Vdd datapath_0/addsub_0/fulladder_0/addsub_one_0[7]/T_xor_b datapath_0/addsub_0/fulladder_0/addsub_one_0[7]/xor3_0/a_7_n16# Vdd pfet w=5 l=5
+  ad=0 pd=0 as=285 ps=124
M3009 datapath_0/addsub_0/fulladder_0/addsub_one_0[7]/xor3_0/a_63_n41# datapath_0/addsub_0/fulladder_0/addsub_one_0[7]/xor3_0/abar datapath_0/latch_2/in7 GND nfet w=4 l=5
+  ad=0 pd=0 as=0 ps=0
M3010 datapath_0/addsub_0/fulladder_0/addsub_one_0[7]/xor3_0/a_7_n16# datapath_0/addsub_0/fulladder_0/addsub_one_0[7]/xor3_0/bbar datapath_0/latch_2/in7 Vdd pfet w=10 l=5
+  ad=0 pd=0 as=130 ps=46
M3011 datapath_0/latch_2/in7 datapath_0/addsub_0/fulladder_0/addsub_one_0[7]/xor3_0/abar datapath_0/addsub_0/fulladder_0/addsub_one_0[7]/xor3_0/a_7_n16# Vdd pfet w=10 l=5
+  ad=0 pd=0 as=0 ps=0
M3012 datapath_0/addsub_0/fulladder_0/addsub_one_0[7]/xor3_0/a_7_n41# datapath_0/addsub_0/fulladder_0/addsub_one_0[7]/cin GND GND nfet w=4 l=5
+  ad=0 pd=0 as=0 ps=0
M3013 datapath_0/addsub_0/fulladder_0/addsub_one_0[7]/xor3_0/a_7_n16# datapath_0/addsub_0/fulladder_0/addsub_one_0[7]/cin Vdd Vdd pfet w=5 l=5
+  ad=0 pd=0 as=0 ps=0
M3014 datapath_0/addsub_0/fulladder_0/addsub_one_0[7]/xor3_1/abar datapath_0/rx7 GND GND nfet w=5 l=2
+  ad=30 pd=22 as=0 ps=0
M3015 datapath_0/addsub_0/fulladder_0/addsub_one_0[7]/xor3_1/abar datapath_0/rx7 Vdd Vdd pfet w=10 l=2
+  ad=60 pd=32 as=0 ps=0
M3016 datapath_0/addsub_0/fulladder_0/addsub_one_0[7]/xor3_1/bbar datapath_0/addsub_0/xor3_0[7]/out GND GND nfet w=5 l=2
+  ad=30 pd=22 as=0 ps=0
M3017 datapath_0/addsub_0/fulladder_0/addsub_one_0[7]/xor3_1/bbar datapath_0/addsub_0/xor3_0[7]/out Vdd Vdd pfet w=10 l=2
+  ad=60 pd=32 as=0 ps=0
M3018 datapath_0/addsub_0/fulladder_0/addsub_one_0[7]/T_xor_b datapath_0/addsub_0/xor3_0[7]/out datapath_0/addsub_0/fulladder_0/addsub_one_0[7]/xor3_1/a_7_n41# GND nfet w=4 l=5
+  ad=121 pd=68 as=68 ps=42
M3019 GND datapath_0/addsub_0/fulladder_0/addsub_one_0[7]/xor3_1/bbar datapath_0/addsub_0/fulladder_0/addsub_one_0[7]/xor3_1/a_63_n41# GND nfet w=4 l=5
+  ad=0 pd=0 as=52 ps=34
M3020 Vdd datapath_0/addsub_0/xor3_0[7]/out datapath_0/addsub_0/fulladder_0/addsub_one_0[7]/xor3_1/a_7_n16# Vdd pfet w=5 l=5
+  ad=0 pd=0 as=285 ps=124
M3021 datapath_0/addsub_0/fulladder_0/addsub_one_0[7]/xor3_1/a_63_n41# datapath_0/addsub_0/fulladder_0/addsub_one_0[7]/xor3_1/abar datapath_0/addsub_0/fulladder_0/addsub_one_0[7]/T_xor_b GND nfet w=4 l=5
+  ad=0 pd=0 as=0 ps=0
M3022 datapath_0/addsub_0/fulladder_0/addsub_one_0[7]/xor3_1/a_7_n16# datapath_0/addsub_0/fulladder_0/addsub_one_0[7]/xor3_1/bbar datapath_0/addsub_0/fulladder_0/addsub_one_0[7]/T_xor_b Vdd pfet w=10 l=5
+  ad=0 pd=0 as=130 ps=46
M3023 datapath_0/addsub_0/fulladder_0/addsub_one_0[7]/T_xor_b datapath_0/addsub_0/fulladder_0/addsub_one_0[7]/xor3_1/abar datapath_0/addsub_0/fulladder_0/addsub_one_0[7]/xor3_1/a_7_n16# Vdd pfet w=10 l=5
+  ad=0 pd=0 as=0 ps=0
M3024 datapath_0/addsub_0/fulladder_0/addsub_one_0[7]/xor3_1/a_7_n41# datapath_0/rx7 GND GND nfet w=4 l=5
+  ad=0 pd=0 as=0 ps=0
M3025 datapath_0/addsub_0/fulladder_0/addsub_one_0[7]/xor3_1/a_7_n16# datapath_0/rx7 Vdd Vdd pfet w=5 l=5
+  ad=0 pd=0 as=0 ps=0
M3026 datapath_0/addsub_0/fulladder_0/addsub_one_0[7]/nand2_2/a_7_10# datapath_0/addsub_0/fulladder_0/addsub_one_0[7]/cin GND GND nfet w=6 l=2
+  ad=42 pd=26 as=0 ps=0
M3027 datapath_0/addsub_0/fulladder_0/addsub_one_0[7]/nand2_3/B datapath_0/addsub_0/fulladder_0/addsub_one_0[7]/cin Vdd Vdd pfet w=12 l=2
+  ad=84 pd=38 as=0 ps=0
M3028 datapath_0/addsub_0/fulladder_0/addsub_one_0[7]/nand2_3/B datapath_0/addsub_0/fulladder_0/addsub_one_0[7]/T_xor_b datapath_0/addsub_0/fulladder_0/addsub_one_0[7]/nand2_2/a_7_10# GND nfet w=6 l=2
+  ad=36 pd=24 as=0 ps=0
M3029 Vdd datapath_0/addsub_0/fulladder_0/addsub_one_0[7]/T_xor_b datapath_0/addsub_0/fulladder_0/addsub_one_0[7]/nand2_3/B Vdd pfet w=12 l=2
+  ad=0 pd=0 as=0 ps=0
M3030 datapath_0/addsub_0/fulladder_0/addsub_one_0[7]/nand2_3/a_7_10# datapath_0/addsub_0/fulladder_0/addsub_one_0[7]/nand2_3/A GND GND nfet w=6 l=2
+  ad=42 pd=26 as=0 ps=0
M3031 datapath_0/addsub_0/cout datapath_0/addsub_0/fulladder_0/addsub_one_0[7]/nand2_3/A Vdd Vdd pfet w=12 l=2
+  ad=84 pd=38 as=0 ps=0
M3032 datapath_0/addsub_0/cout datapath_0/addsub_0/fulladder_0/addsub_one_0[7]/nand2_3/B datapath_0/addsub_0/fulladder_0/addsub_one_0[7]/nand2_3/a_7_10# GND nfet w=6 l=2
+  ad=36 pd=24 as=0 ps=0
M3033 Vdd datapath_0/addsub_0/fulladder_0/addsub_one_0[7]/nand2_3/B datapath_0/addsub_0/cout Vdd pfet w=12 l=2
+  ad=0 pd=0 as=0 ps=0
M3034 datapath_0/addsub_0/fulladder_0/addsub_one_0[7]/nand2_4/a_7_10# datapath_0/rx7 GND GND nfet w=6 l=2
+  ad=42 pd=26 as=0 ps=0
M3035 datapath_0/addsub_0/fulladder_0/addsub_one_0[7]/nand2_3/A datapath_0/rx7 Vdd Vdd pfet w=12 l=2
+  ad=84 pd=38 as=0 ps=0
M3036 datapath_0/addsub_0/fulladder_0/addsub_one_0[7]/nand2_3/A datapath_0/addsub_0/xor3_0[7]/out datapath_0/addsub_0/fulladder_0/addsub_one_0[7]/nand2_4/a_7_10# GND nfet w=6 l=2
+  ad=36 pd=24 as=0 ps=0
M3037 Vdd datapath_0/addsub_0/xor3_0[7]/out datapath_0/addsub_0/fulladder_0/addsub_one_0[7]/nand2_3/A Vdd pfet w=12 l=2
+  ad=0 pd=0 as=0 ps=0
M3038 datapath_0/shift_0/shift_one_0[0]/mux2_0/nand2_1/B Vdd GND GND nfet w=5 l=2
+  ad=30 pd=22 as=0 ps=0
M3039 datapath_0/shift_0/shift_one_0[0]/mux2_0/nand2_1/B Vdd Vdd Vdd pfet w=10 l=2
+  ad=60 pd=32 as=0 ps=0
M3040 datapath_0/shift_0/shift_one_0[0]/mux2_0/nand2_0/a_7_10# Vdd GND GND nfet w=6 l=2
+  ad=42 pd=26 as=0 ps=0
M3041 datapath_0/shift_0/shift_one_0[0]/mux2_0/nand2_2/A Vdd Vdd Vdd pfet w=12 l=2
+  ad=84 pd=38 as=0 ps=0
M3042 datapath_0/shift_0/shift_one_0[0]/mux2_0/nand2_2/A GND datapath_0/shift_0/shift_one_0[0]/mux2_0/nand2_0/a_7_10# GND nfet w=6 l=2
+  ad=36 pd=24 as=0 ps=0
M3043 Vdd GND datapath_0/shift_0/shift_one_0[0]/mux2_0/nand2_2/A Vdd pfet w=12 l=2
+  ad=0 pd=0 as=0 ps=0
M3044 datapath_0/shift_0/shift_one_0[0]/mux2_0/nand2_2/a_7_10# datapath_0/shift_0/shift_one_0[0]/mux2_0/nand2_2/A GND GND nfet w=6 l=2
+  ad=42 pd=26 as=0 ps=0
M3045 datapath_0/shift_0/shift_one_0[0]/mux2_1/B datapath_0/shift_0/shift_one_0[0]/mux2_0/nand2_2/A Vdd Vdd pfet w=12 l=2
+  ad=84 pd=38 as=0 ps=0
M3046 datapath_0/shift_0/shift_one_0[0]/mux2_1/B datapath_0/shift_0/shift_one_0[0]/mux2_0/nand2_2/B datapath_0/shift_0/shift_one_0[0]/mux2_0/nand2_2/a_7_10# GND nfet w=6 l=2
+  ad=36 pd=24 as=0 ps=0
M3047 Vdd datapath_0/shift_0/shift_one_0[0]/mux2_0/nand2_2/B datapath_0/shift_0/shift_one_0[0]/mux2_1/B Vdd pfet w=12 l=2
+  ad=0 pd=0 as=0 ps=0
M3048 datapath_0/shift_0/shift_one_0[0]/mux2_0/nand2_1/a_7_10# datapath_0/rx1 GND GND nfet w=6 l=2
+  ad=42 pd=26 as=0 ps=0
M3049 datapath_0/shift_0/shift_one_0[0]/mux2_0/nand2_2/B datapath_0/rx1 Vdd Vdd pfet w=12 l=2
+  ad=84 pd=38 as=0 ps=0
M3050 datapath_0/shift_0/shift_one_0[0]/mux2_0/nand2_2/B datapath_0/shift_0/shift_one_0[0]/mux2_0/nand2_1/B datapath_0/shift_0/shift_one_0[0]/mux2_0/nand2_1/a_7_10# GND nfet w=6 l=2
+  ad=36 pd=24 as=0 ps=0
M3051 Vdd datapath_0/shift_0/shift_one_0[0]/mux2_0/nand2_1/B datapath_0/shift_0/shift_one_0[0]/mux2_0/nand2_2/B Vdd pfet w=12 l=2
+  ad=0 pd=0 as=0 ps=0
M3052 datapath_0/shift_0/shift_one_0[0]/mux2_1/nand2_1/B Vdd GND GND nfet w=5 l=2
+  ad=30 pd=22 as=0 ps=0
M3053 datapath_0/shift_0/shift_one_0[0]/mux2_1/nand2_1/B Vdd Vdd Vdd pfet w=10 l=2
+  ad=60 pd=32 as=0 ps=0
M3054 datapath_0/shift_0/shift_one_0[0]/mux2_1/nand2_0/a_7_10# Vdd GND GND nfet w=6 l=2
+  ad=42 pd=26 as=0 ps=0
M3055 datapath_0/shift_0/shift_one_0[0]/mux2_1/nand2_2/A Vdd Vdd Vdd pfet w=12 l=2
+  ad=84 pd=38 as=0 ps=0
M3056 datapath_0/shift_0/shift_one_0[0]/mux2_1/nand2_2/A datapath_0/shift_0/shift_one_0[0]/mux2_1/B datapath_0/shift_0/shift_one_0[0]/mux2_1/nand2_0/a_7_10# GND nfet w=6 l=2
+  ad=36 pd=24 as=0 ps=0
M3057 Vdd datapath_0/shift_0/shift_one_0[0]/mux2_1/B datapath_0/shift_0/shift_one_0[0]/mux2_1/nand2_2/A Vdd pfet w=12 l=2
+  ad=0 pd=0 as=0 ps=0
M3058 datapath_0/shift_0/shift_one_0[0]/mux2_1/nand2_2/a_7_10# datapath_0/shift_0/shift_one_0[0]/mux2_1/nand2_2/A GND GND nfet w=6 l=2
+  ad=42 pd=26 as=0 ps=0
M3059 datapath_0/so0 datapath_0/shift_0/shift_one_0[0]/mux2_1/nand2_2/A Vdd Vdd pfet w=12 l=2
+  ad=84 pd=38 as=0 ps=0
M3060 datapath_0/so0 datapath_0/shift_0/shift_one_0[0]/mux2_1/nand2_2/B datapath_0/shift_0/shift_one_0[0]/mux2_1/nand2_2/a_7_10# GND nfet w=6 l=2
+  ad=36 pd=24 as=0 ps=0
M3061 Vdd datapath_0/shift_0/shift_one_0[0]/mux2_1/nand2_2/B datapath_0/so0 Vdd pfet w=12 l=2
+  ad=0 pd=0 as=0 ps=0
M3062 datapath_0/shift_0/shift_one_0[0]/mux2_1/nand2_1/a_7_10# datapath_0/rx0 GND GND nfet w=6 l=2
+  ad=42 pd=26 as=0 ps=0
M3063 datapath_0/shift_0/shift_one_0[0]/mux2_1/nand2_2/B datapath_0/rx0 Vdd Vdd pfet w=12 l=2
+  ad=84 pd=38 as=0 ps=0
M3064 datapath_0/shift_0/shift_one_0[0]/mux2_1/nand2_2/B datapath_0/shift_0/shift_one_0[0]/mux2_1/nand2_1/B datapath_0/shift_0/shift_one_0[0]/mux2_1/nand2_1/a_7_10# GND nfet w=6 l=2
+  ad=36 pd=24 as=0 ps=0
M3065 Vdd datapath_0/shift_0/shift_one_0[0]/mux2_1/nand2_1/B datapath_0/shift_0/shift_one_0[0]/mux2_1/nand2_2/B Vdd pfet w=12 l=2
+  ad=0 pd=0 as=0 ps=0
M3066 datapath_0/shift_0/shift_one_0[1]/mux2_0/nand2_1/B Vdd GND GND nfet w=5 l=2
+  ad=30 pd=22 as=0 ps=0
M3067 datapath_0/shift_0/shift_one_0[1]/mux2_0/nand2_1/B Vdd Vdd Vdd pfet w=10 l=2
+  ad=60 pd=32 as=0 ps=0
M3068 datapath_0/shift_0/shift_one_0[1]/mux2_0/nand2_0/a_7_10# Vdd GND GND nfet w=6 l=2
+  ad=42 pd=26 as=0 ps=0
M3069 datapath_0/shift_0/shift_one_0[1]/mux2_0/nand2_2/A Vdd Vdd Vdd pfet w=12 l=2
+  ad=84 pd=38 as=0 ps=0
M3070 datapath_0/shift_0/shift_one_0[1]/mux2_0/nand2_2/A datapath_0/rx0 datapath_0/shift_0/shift_one_0[1]/mux2_0/nand2_0/a_7_10# GND nfet w=6 l=2
+  ad=36 pd=24 as=0 ps=0
M3071 Vdd datapath_0/rx0 datapath_0/shift_0/shift_one_0[1]/mux2_0/nand2_2/A Vdd pfet w=12 l=2
+  ad=0 pd=0 as=0 ps=0
M3072 datapath_0/shift_0/shift_one_0[1]/mux2_0/nand2_2/a_7_10# datapath_0/shift_0/shift_one_0[1]/mux2_0/nand2_2/A GND GND nfet w=6 l=2
+  ad=42 pd=26 as=0 ps=0
M3073 datapath_0/shift_0/shift_one_0[1]/mux2_1/B datapath_0/shift_0/shift_one_0[1]/mux2_0/nand2_2/A Vdd Vdd pfet w=12 l=2
+  ad=84 pd=38 as=0 ps=0
M3074 datapath_0/shift_0/shift_one_0[1]/mux2_1/B datapath_0/shift_0/shift_one_0[1]/mux2_0/nand2_2/B datapath_0/shift_0/shift_one_0[1]/mux2_0/nand2_2/a_7_10# GND nfet w=6 l=2
+  ad=36 pd=24 as=0 ps=0
M3075 Vdd datapath_0/shift_0/shift_one_0[1]/mux2_0/nand2_2/B datapath_0/shift_0/shift_one_0[1]/mux2_1/B Vdd pfet w=12 l=2
+  ad=0 pd=0 as=0 ps=0
M3076 datapath_0/shift_0/shift_one_0[1]/mux2_0/nand2_1/a_7_10# datapath_0/rx2 GND GND nfet w=6 l=2
+  ad=42 pd=26 as=0 ps=0
M3077 datapath_0/shift_0/shift_one_0[1]/mux2_0/nand2_2/B datapath_0/rx2 Vdd Vdd pfet w=12 l=2
+  ad=84 pd=38 as=0 ps=0
M3078 datapath_0/shift_0/shift_one_0[1]/mux2_0/nand2_2/B datapath_0/shift_0/shift_one_0[1]/mux2_0/nand2_1/B datapath_0/shift_0/shift_one_0[1]/mux2_0/nand2_1/a_7_10# GND nfet w=6 l=2
+  ad=36 pd=24 as=0 ps=0
M3079 Vdd datapath_0/shift_0/shift_one_0[1]/mux2_0/nand2_1/B datapath_0/shift_0/shift_one_0[1]/mux2_0/nand2_2/B Vdd pfet w=12 l=2
+  ad=0 pd=0 as=0 ps=0
M3080 datapath_0/shift_0/shift_one_0[1]/mux2_1/nand2_1/B Vdd GND GND nfet w=5 l=2
+  ad=30 pd=22 as=0 ps=0
M3081 datapath_0/shift_0/shift_one_0[1]/mux2_1/nand2_1/B Vdd Vdd Vdd pfet w=10 l=2
+  ad=60 pd=32 as=0 ps=0
M3082 datapath_0/shift_0/shift_one_0[1]/mux2_1/nand2_0/a_7_10# Vdd GND GND nfet w=6 l=2
+  ad=42 pd=26 as=0 ps=0
M3083 datapath_0/shift_0/shift_one_0[1]/mux2_1/nand2_2/A Vdd Vdd Vdd pfet w=12 l=2
+  ad=84 pd=38 as=0 ps=0
M3084 datapath_0/shift_0/shift_one_0[1]/mux2_1/nand2_2/A datapath_0/shift_0/shift_one_0[1]/mux2_1/B datapath_0/shift_0/shift_one_0[1]/mux2_1/nand2_0/a_7_10# GND nfet w=6 l=2
+  ad=36 pd=24 as=0 ps=0
M3085 Vdd datapath_0/shift_0/shift_one_0[1]/mux2_1/B datapath_0/shift_0/shift_one_0[1]/mux2_1/nand2_2/A Vdd pfet w=12 l=2
+  ad=0 pd=0 as=0 ps=0
M3086 datapath_0/shift_0/shift_one_0[1]/mux2_1/nand2_2/a_7_10# datapath_0/shift_0/shift_one_0[1]/mux2_1/nand2_2/A GND GND nfet w=6 l=2
+  ad=42 pd=26 as=0 ps=0
M3087 datapath_0/so1 datapath_0/shift_0/shift_one_0[1]/mux2_1/nand2_2/A Vdd Vdd pfet w=12 l=2
+  ad=84 pd=38 as=0 ps=0
M3088 datapath_0/so1 datapath_0/shift_0/shift_one_0[1]/mux2_1/nand2_2/B datapath_0/shift_0/shift_one_0[1]/mux2_1/nand2_2/a_7_10# GND nfet w=6 l=2
+  ad=36 pd=24 as=0 ps=0
M3089 Vdd datapath_0/shift_0/shift_one_0[1]/mux2_1/nand2_2/B datapath_0/so1 Vdd pfet w=12 l=2
+  ad=0 pd=0 as=0 ps=0
M3090 datapath_0/shift_0/shift_one_0[1]/mux2_1/nand2_1/a_7_10# datapath_0/rx1 GND GND nfet w=6 l=2
+  ad=42 pd=26 as=0 ps=0
M3091 datapath_0/shift_0/shift_one_0[1]/mux2_1/nand2_2/B datapath_0/rx1 Vdd Vdd pfet w=12 l=2
+  ad=84 pd=38 as=0 ps=0
M3092 datapath_0/shift_0/shift_one_0[1]/mux2_1/nand2_2/B datapath_0/shift_0/shift_one_0[1]/mux2_1/nand2_1/B datapath_0/shift_0/shift_one_0[1]/mux2_1/nand2_1/a_7_10# GND nfet w=6 l=2
+  ad=36 pd=24 as=0 ps=0
M3093 Vdd datapath_0/shift_0/shift_one_0[1]/mux2_1/nand2_1/B datapath_0/shift_0/shift_one_0[1]/mux2_1/nand2_2/B Vdd pfet w=12 l=2
+  ad=0 pd=0 as=0 ps=0
M3094 datapath_0/shift_0/shift_one_0[2]/mux2_0/nand2_1/B Vdd GND GND nfet w=5 l=2
+  ad=30 pd=22 as=0 ps=0
M3095 datapath_0/shift_0/shift_one_0[2]/mux2_0/nand2_1/B Vdd Vdd Vdd pfet w=10 l=2
+  ad=60 pd=32 as=0 ps=0
M3096 datapath_0/shift_0/shift_one_0[2]/mux2_0/nand2_0/a_7_10# Vdd GND GND nfet w=6 l=2
+  ad=42 pd=26 as=0 ps=0
M3097 datapath_0/shift_0/shift_one_0[2]/mux2_0/nand2_2/A Vdd Vdd Vdd pfet w=12 l=2
+  ad=84 pd=38 as=0 ps=0
M3098 datapath_0/shift_0/shift_one_0[2]/mux2_0/nand2_2/A datapath_0/rx1 datapath_0/shift_0/shift_one_0[2]/mux2_0/nand2_0/a_7_10# GND nfet w=6 l=2
+  ad=36 pd=24 as=0 ps=0
M3099 Vdd datapath_0/rx1 datapath_0/shift_0/shift_one_0[2]/mux2_0/nand2_2/A Vdd pfet w=12 l=2
+  ad=0 pd=0 as=0 ps=0
M3100 datapath_0/shift_0/shift_one_0[2]/mux2_0/nand2_2/a_7_10# datapath_0/shift_0/shift_one_0[2]/mux2_0/nand2_2/A GND GND nfet w=6 l=2
+  ad=42 pd=26 as=0 ps=0
M3101 datapath_0/shift_0/shift_one_0[2]/mux2_1/B datapath_0/shift_0/shift_one_0[2]/mux2_0/nand2_2/A Vdd Vdd pfet w=12 l=2
+  ad=84 pd=38 as=0 ps=0
M3102 datapath_0/shift_0/shift_one_0[2]/mux2_1/B datapath_0/shift_0/shift_one_0[2]/mux2_0/nand2_2/B datapath_0/shift_0/shift_one_0[2]/mux2_0/nand2_2/a_7_10# GND nfet w=6 l=2
+  ad=36 pd=24 as=0 ps=0
M3103 Vdd datapath_0/shift_0/shift_one_0[2]/mux2_0/nand2_2/B datapath_0/shift_0/shift_one_0[2]/mux2_1/B Vdd pfet w=12 l=2
+  ad=0 pd=0 as=0 ps=0
M3104 datapath_0/shift_0/shift_one_0[2]/mux2_0/nand2_1/a_7_10# datapath_0/rx3 GND GND nfet w=6 l=2
+  ad=42 pd=26 as=0 ps=0
M3105 datapath_0/shift_0/shift_one_0[2]/mux2_0/nand2_2/B datapath_0/rx3 Vdd Vdd pfet w=12 l=2
+  ad=84 pd=38 as=0 ps=0
M3106 datapath_0/shift_0/shift_one_0[2]/mux2_0/nand2_2/B datapath_0/shift_0/shift_one_0[2]/mux2_0/nand2_1/B datapath_0/shift_0/shift_one_0[2]/mux2_0/nand2_1/a_7_10# GND nfet w=6 l=2
+  ad=36 pd=24 as=0 ps=0
M3107 Vdd datapath_0/shift_0/shift_one_0[2]/mux2_0/nand2_1/B datapath_0/shift_0/shift_one_0[2]/mux2_0/nand2_2/B Vdd pfet w=12 l=2
+  ad=0 pd=0 as=0 ps=0
M3108 datapath_0/shift_0/shift_one_0[2]/mux2_1/nand2_1/B Vdd GND GND nfet w=5 l=2
+  ad=30 pd=22 as=0 ps=0
M3109 datapath_0/shift_0/shift_one_0[2]/mux2_1/nand2_1/B Vdd Vdd Vdd pfet w=10 l=2
+  ad=60 pd=32 as=0 ps=0
M3110 datapath_0/shift_0/shift_one_0[2]/mux2_1/nand2_0/a_7_10# Vdd GND GND nfet w=6 l=2
+  ad=42 pd=26 as=0 ps=0
M3111 datapath_0/shift_0/shift_one_0[2]/mux2_1/nand2_2/A Vdd Vdd Vdd pfet w=12 l=2
+  ad=84 pd=38 as=0 ps=0
M3112 datapath_0/shift_0/shift_one_0[2]/mux2_1/nand2_2/A datapath_0/shift_0/shift_one_0[2]/mux2_1/B datapath_0/shift_0/shift_one_0[2]/mux2_1/nand2_0/a_7_10# GND nfet w=6 l=2
+  ad=36 pd=24 as=0 ps=0
M3113 Vdd datapath_0/shift_0/shift_one_0[2]/mux2_1/B datapath_0/shift_0/shift_one_0[2]/mux2_1/nand2_2/A Vdd pfet w=12 l=2
+  ad=0 pd=0 as=0 ps=0
M3114 datapath_0/shift_0/shift_one_0[2]/mux2_1/nand2_2/a_7_10# datapath_0/shift_0/shift_one_0[2]/mux2_1/nand2_2/A GND GND nfet w=6 l=2
+  ad=42 pd=26 as=0 ps=0
M3115 datapath_0/so2 datapath_0/shift_0/shift_one_0[2]/mux2_1/nand2_2/A Vdd Vdd pfet w=12 l=2
+  ad=84 pd=38 as=0 ps=0
M3116 datapath_0/so2 datapath_0/shift_0/shift_one_0[2]/mux2_1/nand2_2/B datapath_0/shift_0/shift_one_0[2]/mux2_1/nand2_2/a_7_10# GND nfet w=6 l=2
+  ad=36 pd=24 as=0 ps=0
M3117 Vdd datapath_0/shift_0/shift_one_0[2]/mux2_1/nand2_2/B datapath_0/so2 Vdd pfet w=12 l=2
+  ad=0 pd=0 as=0 ps=0
M3118 datapath_0/shift_0/shift_one_0[2]/mux2_1/nand2_1/a_7_10# datapath_0/rx2 GND GND nfet w=6 l=2
+  ad=42 pd=26 as=0 ps=0
M3119 datapath_0/shift_0/shift_one_0[2]/mux2_1/nand2_2/B datapath_0/rx2 Vdd Vdd pfet w=12 l=2
+  ad=84 pd=38 as=0 ps=0
M3120 datapath_0/shift_0/shift_one_0[2]/mux2_1/nand2_2/B datapath_0/shift_0/shift_one_0[2]/mux2_1/nand2_1/B datapath_0/shift_0/shift_one_0[2]/mux2_1/nand2_1/a_7_10# GND nfet w=6 l=2
+  ad=36 pd=24 as=0 ps=0
M3121 Vdd datapath_0/shift_0/shift_one_0[2]/mux2_1/nand2_1/B datapath_0/shift_0/shift_one_0[2]/mux2_1/nand2_2/B Vdd pfet w=12 l=2
+  ad=0 pd=0 as=0 ps=0
M3122 datapath_0/shift_0/shift_one_0[3]/mux2_0/nand2_1/B Vdd GND GND nfet w=5 l=2
+  ad=30 pd=22 as=0 ps=0
M3123 datapath_0/shift_0/shift_one_0[3]/mux2_0/nand2_1/B Vdd Vdd Vdd pfet w=10 l=2
+  ad=60 pd=32 as=0 ps=0
M3124 datapath_0/shift_0/shift_one_0[3]/mux2_0/nand2_0/a_7_10# Vdd GND GND nfet w=6 l=2
+  ad=42 pd=26 as=0 ps=0
M3125 datapath_0/shift_0/shift_one_0[3]/mux2_0/nand2_2/A Vdd Vdd Vdd pfet w=12 l=2
+  ad=84 pd=38 as=0 ps=0
M3126 datapath_0/shift_0/shift_one_0[3]/mux2_0/nand2_2/A datapath_0/rx2 datapath_0/shift_0/shift_one_0[3]/mux2_0/nand2_0/a_7_10# GND nfet w=6 l=2
+  ad=36 pd=24 as=0 ps=0
M3127 Vdd datapath_0/rx2 datapath_0/shift_0/shift_one_0[3]/mux2_0/nand2_2/A Vdd pfet w=12 l=2
+  ad=0 pd=0 as=0 ps=0
M3128 datapath_0/shift_0/shift_one_0[3]/mux2_0/nand2_2/a_7_10# datapath_0/shift_0/shift_one_0[3]/mux2_0/nand2_2/A GND GND nfet w=6 l=2
+  ad=42 pd=26 as=0 ps=0
M3129 datapath_0/shift_0/shift_one_0[3]/mux2_1/B datapath_0/shift_0/shift_one_0[3]/mux2_0/nand2_2/A Vdd Vdd pfet w=12 l=2
+  ad=84 pd=38 as=0 ps=0
M3130 datapath_0/shift_0/shift_one_0[3]/mux2_1/B datapath_0/shift_0/shift_one_0[3]/mux2_0/nand2_2/B datapath_0/shift_0/shift_one_0[3]/mux2_0/nand2_2/a_7_10# GND nfet w=6 l=2
+  ad=36 pd=24 as=0 ps=0
M3131 Vdd datapath_0/shift_0/shift_one_0[3]/mux2_0/nand2_2/B datapath_0/shift_0/shift_one_0[3]/mux2_1/B Vdd pfet w=12 l=2
+  ad=0 pd=0 as=0 ps=0
M3132 datapath_0/shift_0/shift_one_0[3]/mux2_0/nand2_1/a_7_10# datapath_0/rx4 GND GND nfet w=6 l=2
+  ad=42 pd=26 as=0 ps=0
M3133 datapath_0/shift_0/shift_one_0[3]/mux2_0/nand2_2/B datapath_0/rx4 Vdd Vdd pfet w=12 l=2
+  ad=84 pd=38 as=0 ps=0
M3134 datapath_0/shift_0/shift_one_0[3]/mux2_0/nand2_2/B datapath_0/shift_0/shift_one_0[3]/mux2_0/nand2_1/B datapath_0/shift_0/shift_one_0[3]/mux2_0/nand2_1/a_7_10# GND nfet w=6 l=2
+  ad=36 pd=24 as=0 ps=0
M3135 Vdd datapath_0/shift_0/shift_one_0[3]/mux2_0/nand2_1/B datapath_0/shift_0/shift_one_0[3]/mux2_0/nand2_2/B Vdd pfet w=12 l=2
+  ad=0 pd=0 as=0 ps=0
M3136 datapath_0/shift_0/shift_one_0[3]/mux2_1/nand2_1/B Vdd GND GND nfet w=5 l=2
+  ad=30 pd=22 as=0 ps=0
M3137 datapath_0/shift_0/shift_one_0[3]/mux2_1/nand2_1/B Vdd Vdd Vdd pfet w=10 l=2
+  ad=60 pd=32 as=0 ps=0
M3138 datapath_0/shift_0/shift_one_0[3]/mux2_1/nand2_0/a_7_10# Vdd GND GND nfet w=6 l=2
+  ad=42 pd=26 as=0 ps=0
M3139 datapath_0/shift_0/shift_one_0[3]/mux2_1/nand2_2/A Vdd Vdd Vdd pfet w=12 l=2
+  ad=84 pd=38 as=0 ps=0
M3140 datapath_0/shift_0/shift_one_0[3]/mux2_1/nand2_2/A datapath_0/shift_0/shift_one_0[3]/mux2_1/B datapath_0/shift_0/shift_one_0[3]/mux2_1/nand2_0/a_7_10# GND nfet w=6 l=2
+  ad=36 pd=24 as=0 ps=0
M3141 Vdd datapath_0/shift_0/shift_one_0[3]/mux2_1/B datapath_0/shift_0/shift_one_0[3]/mux2_1/nand2_2/A Vdd pfet w=12 l=2
+  ad=0 pd=0 as=0 ps=0
M3142 datapath_0/shift_0/shift_one_0[3]/mux2_1/nand2_2/a_7_10# datapath_0/shift_0/shift_one_0[3]/mux2_1/nand2_2/A GND GND nfet w=6 l=2
+  ad=42 pd=26 as=0 ps=0
M3143 datapath_0/so3 datapath_0/shift_0/shift_one_0[3]/mux2_1/nand2_2/A Vdd Vdd pfet w=12 l=2
+  ad=84 pd=38 as=0 ps=0
M3144 datapath_0/so3 datapath_0/shift_0/shift_one_0[3]/mux2_1/nand2_2/B datapath_0/shift_0/shift_one_0[3]/mux2_1/nand2_2/a_7_10# GND nfet w=6 l=2
+  ad=36 pd=24 as=0 ps=0
M3145 Vdd datapath_0/shift_0/shift_one_0[3]/mux2_1/nand2_2/B datapath_0/so3 Vdd pfet w=12 l=2
+  ad=0 pd=0 as=0 ps=0
M3146 datapath_0/shift_0/shift_one_0[3]/mux2_1/nand2_1/a_7_10# datapath_0/rx3 GND GND nfet w=6 l=2
+  ad=42 pd=26 as=0 ps=0
M3147 datapath_0/shift_0/shift_one_0[3]/mux2_1/nand2_2/B datapath_0/rx3 Vdd Vdd pfet w=12 l=2
+  ad=84 pd=38 as=0 ps=0
M3148 datapath_0/shift_0/shift_one_0[3]/mux2_1/nand2_2/B datapath_0/shift_0/shift_one_0[3]/mux2_1/nand2_1/B datapath_0/shift_0/shift_one_0[3]/mux2_1/nand2_1/a_7_10# GND nfet w=6 l=2
+  ad=36 pd=24 as=0 ps=0
M3149 Vdd datapath_0/shift_0/shift_one_0[3]/mux2_1/nand2_1/B datapath_0/shift_0/shift_one_0[3]/mux2_1/nand2_2/B Vdd pfet w=12 l=2
+  ad=0 pd=0 as=0 ps=0
M3150 datapath_0/shift_0/shift_one_0[4]/mux2_0/nand2_1/B Vdd GND GND nfet w=5 l=2
+  ad=30 pd=22 as=0 ps=0
M3151 datapath_0/shift_0/shift_one_0[4]/mux2_0/nand2_1/B Vdd Vdd Vdd pfet w=10 l=2
+  ad=60 pd=32 as=0 ps=0
M3152 datapath_0/shift_0/shift_one_0[4]/mux2_0/nand2_0/a_7_10# Vdd GND GND nfet w=6 l=2
+  ad=42 pd=26 as=0 ps=0
M3153 datapath_0/shift_0/shift_one_0[4]/mux2_0/nand2_2/A Vdd Vdd Vdd pfet w=12 l=2
+  ad=84 pd=38 as=0 ps=0
M3154 datapath_0/shift_0/shift_one_0[4]/mux2_0/nand2_2/A datapath_0/rx3 datapath_0/shift_0/shift_one_0[4]/mux2_0/nand2_0/a_7_10# GND nfet w=6 l=2
+  ad=36 pd=24 as=0 ps=0
M3155 Vdd datapath_0/rx3 datapath_0/shift_0/shift_one_0[4]/mux2_0/nand2_2/A Vdd pfet w=12 l=2
+  ad=0 pd=0 as=0 ps=0
M3156 datapath_0/shift_0/shift_one_0[4]/mux2_0/nand2_2/a_7_10# datapath_0/shift_0/shift_one_0[4]/mux2_0/nand2_2/A GND GND nfet w=6 l=2
+  ad=42 pd=26 as=0 ps=0
M3157 datapath_0/shift_0/shift_one_0[4]/mux2_1/B datapath_0/shift_0/shift_one_0[4]/mux2_0/nand2_2/A Vdd Vdd pfet w=12 l=2
+  ad=84 pd=38 as=0 ps=0
M3158 datapath_0/shift_0/shift_one_0[4]/mux2_1/B datapath_0/shift_0/shift_one_0[4]/mux2_0/nand2_2/B datapath_0/shift_0/shift_one_0[4]/mux2_0/nand2_2/a_7_10# GND nfet w=6 l=2
+  ad=36 pd=24 as=0 ps=0
M3159 Vdd datapath_0/shift_0/shift_one_0[4]/mux2_0/nand2_2/B datapath_0/shift_0/shift_one_0[4]/mux2_1/B Vdd pfet w=12 l=2
+  ad=0 pd=0 as=0 ps=0
M3160 datapath_0/shift_0/shift_one_0[4]/mux2_0/nand2_1/a_7_10# datapath_0/rx5 GND GND nfet w=6 l=2
+  ad=42 pd=26 as=0 ps=0
M3161 datapath_0/shift_0/shift_one_0[4]/mux2_0/nand2_2/B datapath_0/rx5 Vdd Vdd pfet w=12 l=2
+  ad=84 pd=38 as=0 ps=0
M3162 datapath_0/shift_0/shift_one_0[4]/mux2_0/nand2_2/B datapath_0/shift_0/shift_one_0[4]/mux2_0/nand2_1/B datapath_0/shift_0/shift_one_0[4]/mux2_0/nand2_1/a_7_10# GND nfet w=6 l=2
+  ad=36 pd=24 as=0 ps=0
M3163 Vdd datapath_0/shift_0/shift_one_0[4]/mux2_0/nand2_1/B datapath_0/shift_0/shift_one_0[4]/mux2_0/nand2_2/B Vdd pfet w=12 l=2
+  ad=0 pd=0 as=0 ps=0
M3164 datapath_0/shift_0/shift_one_0[4]/mux2_1/nand2_1/B Vdd GND GND nfet w=5 l=2
+  ad=30 pd=22 as=0 ps=0
M3165 datapath_0/shift_0/shift_one_0[4]/mux2_1/nand2_1/B Vdd Vdd Vdd pfet w=10 l=2
+  ad=60 pd=32 as=0 ps=0
M3166 datapath_0/shift_0/shift_one_0[4]/mux2_1/nand2_0/a_7_10# Vdd GND GND nfet w=6 l=2
+  ad=42 pd=26 as=0 ps=0
M3167 datapath_0/shift_0/shift_one_0[4]/mux2_1/nand2_2/A Vdd Vdd Vdd pfet w=12 l=2
+  ad=84 pd=38 as=0 ps=0
M3168 datapath_0/shift_0/shift_one_0[4]/mux2_1/nand2_2/A datapath_0/shift_0/shift_one_0[4]/mux2_1/B datapath_0/shift_0/shift_one_0[4]/mux2_1/nand2_0/a_7_10# GND nfet w=6 l=2
+  ad=36 pd=24 as=0 ps=0
M3169 Vdd datapath_0/shift_0/shift_one_0[4]/mux2_1/B datapath_0/shift_0/shift_one_0[4]/mux2_1/nand2_2/A Vdd pfet w=12 l=2
+  ad=0 pd=0 as=0 ps=0
M3170 datapath_0/shift_0/shift_one_0[4]/mux2_1/nand2_2/a_7_10# datapath_0/shift_0/shift_one_0[4]/mux2_1/nand2_2/A GND GND nfet w=6 l=2
+  ad=42 pd=26 as=0 ps=0
M3171 datapath_0/so4 datapath_0/shift_0/shift_one_0[4]/mux2_1/nand2_2/A Vdd Vdd pfet w=12 l=2
+  ad=84 pd=38 as=0 ps=0
M3172 datapath_0/so4 datapath_0/shift_0/shift_one_0[4]/mux2_1/nand2_2/B datapath_0/shift_0/shift_one_0[4]/mux2_1/nand2_2/a_7_10# GND nfet w=6 l=2
+  ad=36 pd=24 as=0 ps=0
M3173 Vdd datapath_0/shift_0/shift_one_0[4]/mux2_1/nand2_2/B datapath_0/so4 Vdd pfet w=12 l=2
+  ad=0 pd=0 as=0 ps=0
M3174 datapath_0/shift_0/shift_one_0[4]/mux2_1/nand2_1/a_7_10# datapath_0/rx4 GND GND nfet w=6 l=2
+  ad=42 pd=26 as=0 ps=0
M3175 datapath_0/shift_0/shift_one_0[4]/mux2_1/nand2_2/B datapath_0/rx4 Vdd Vdd pfet w=12 l=2
+  ad=84 pd=38 as=0 ps=0
M3176 datapath_0/shift_0/shift_one_0[4]/mux2_1/nand2_2/B datapath_0/shift_0/shift_one_0[4]/mux2_1/nand2_1/B datapath_0/shift_0/shift_one_0[4]/mux2_1/nand2_1/a_7_10# GND nfet w=6 l=2
+  ad=36 pd=24 as=0 ps=0
M3177 Vdd datapath_0/shift_0/shift_one_0[4]/mux2_1/nand2_1/B datapath_0/shift_0/shift_one_0[4]/mux2_1/nand2_2/B Vdd pfet w=12 l=2
+  ad=0 pd=0 as=0 ps=0
M3178 datapath_0/shift_0/shift_one_0[5]/mux2_0/nand2_1/B Vdd GND GND nfet w=5 l=2
+  ad=30 pd=22 as=0 ps=0
M3179 datapath_0/shift_0/shift_one_0[5]/mux2_0/nand2_1/B Vdd Vdd Vdd pfet w=10 l=2
+  ad=60 pd=32 as=0 ps=0
M3180 datapath_0/shift_0/shift_one_0[5]/mux2_0/nand2_0/a_7_10# Vdd GND GND nfet w=6 l=2
+  ad=42 pd=26 as=0 ps=0
M3181 datapath_0/shift_0/shift_one_0[5]/mux2_0/nand2_2/A Vdd Vdd Vdd pfet w=12 l=2
+  ad=84 pd=38 as=0 ps=0
M3182 datapath_0/shift_0/shift_one_0[5]/mux2_0/nand2_2/A datapath_0/rx4 datapath_0/shift_0/shift_one_0[5]/mux2_0/nand2_0/a_7_10# GND nfet w=6 l=2
+  ad=36 pd=24 as=0 ps=0
M3183 Vdd datapath_0/rx4 datapath_0/shift_0/shift_one_0[5]/mux2_0/nand2_2/A Vdd pfet w=12 l=2
+  ad=0 pd=0 as=0 ps=0
M3184 datapath_0/shift_0/shift_one_0[5]/mux2_0/nand2_2/a_7_10# datapath_0/shift_0/shift_one_0[5]/mux2_0/nand2_2/A GND GND nfet w=6 l=2
+  ad=42 pd=26 as=0 ps=0
M3185 datapath_0/shift_0/shift_one_0[5]/mux2_1/B datapath_0/shift_0/shift_one_0[5]/mux2_0/nand2_2/A Vdd Vdd pfet w=12 l=2
+  ad=84 pd=38 as=0 ps=0
M3186 datapath_0/shift_0/shift_one_0[5]/mux2_1/B datapath_0/shift_0/shift_one_0[5]/mux2_0/nand2_2/B datapath_0/shift_0/shift_one_0[5]/mux2_0/nand2_2/a_7_10# GND nfet w=6 l=2
+  ad=36 pd=24 as=0 ps=0
M3187 Vdd datapath_0/shift_0/shift_one_0[5]/mux2_0/nand2_2/B datapath_0/shift_0/shift_one_0[5]/mux2_1/B Vdd pfet w=12 l=2
+  ad=0 pd=0 as=0 ps=0
M3188 datapath_0/shift_0/shift_one_0[5]/mux2_0/nand2_1/a_7_10# datapath_0/rx6 GND GND nfet w=6 l=2
+  ad=42 pd=26 as=0 ps=0
M3189 datapath_0/shift_0/shift_one_0[5]/mux2_0/nand2_2/B datapath_0/rx6 Vdd Vdd pfet w=12 l=2
+  ad=84 pd=38 as=0 ps=0
M3190 datapath_0/shift_0/shift_one_0[5]/mux2_0/nand2_2/B datapath_0/shift_0/shift_one_0[5]/mux2_0/nand2_1/B datapath_0/shift_0/shift_one_0[5]/mux2_0/nand2_1/a_7_10# GND nfet w=6 l=2
+  ad=36 pd=24 as=0 ps=0
M3191 Vdd datapath_0/shift_0/shift_one_0[5]/mux2_0/nand2_1/B datapath_0/shift_0/shift_one_0[5]/mux2_0/nand2_2/B Vdd pfet w=12 l=2
+  ad=0 pd=0 as=0 ps=0
M3192 datapath_0/shift_0/shift_one_0[5]/mux2_1/nand2_1/B Vdd GND GND nfet w=5 l=2
+  ad=30 pd=22 as=0 ps=0
M3193 datapath_0/shift_0/shift_one_0[5]/mux2_1/nand2_1/B Vdd Vdd Vdd pfet w=10 l=2
+  ad=60 pd=32 as=0 ps=0
M3194 datapath_0/shift_0/shift_one_0[5]/mux2_1/nand2_0/a_7_10# Vdd GND GND nfet w=6 l=2
+  ad=42 pd=26 as=0 ps=0
M3195 datapath_0/shift_0/shift_one_0[5]/mux2_1/nand2_2/A Vdd Vdd Vdd pfet w=12 l=2
+  ad=84 pd=38 as=0 ps=0
M3196 datapath_0/shift_0/shift_one_0[5]/mux2_1/nand2_2/A datapath_0/shift_0/shift_one_0[5]/mux2_1/B datapath_0/shift_0/shift_one_0[5]/mux2_1/nand2_0/a_7_10# GND nfet w=6 l=2
+  ad=36 pd=24 as=0 ps=0
M3197 Vdd datapath_0/shift_0/shift_one_0[5]/mux2_1/B datapath_0/shift_0/shift_one_0[5]/mux2_1/nand2_2/A Vdd pfet w=12 l=2
+  ad=0 pd=0 as=0 ps=0
M3198 datapath_0/shift_0/shift_one_0[5]/mux2_1/nand2_2/a_7_10# datapath_0/shift_0/shift_one_0[5]/mux2_1/nand2_2/A GND GND nfet w=6 l=2
+  ad=42 pd=26 as=0 ps=0
M3199 datapath_0/so5 datapath_0/shift_0/shift_one_0[5]/mux2_1/nand2_2/A Vdd Vdd pfet w=12 l=2
+  ad=84 pd=38 as=0 ps=0
M3200 datapath_0/so5 datapath_0/shift_0/shift_one_0[5]/mux2_1/nand2_2/B datapath_0/shift_0/shift_one_0[5]/mux2_1/nand2_2/a_7_10# GND nfet w=6 l=2
+  ad=36 pd=24 as=0 ps=0
M3201 Vdd datapath_0/shift_0/shift_one_0[5]/mux2_1/nand2_2/B datapath_0/so5 Vdd pfet w=12 l=2
+  ad=0 pd=0 as=0 ps=0
M3202 datapath_0/shift_0/shift_one_0[5]/mux2_1/nand2_1/a_7_10# datapath_0/rx5 GND GND nfet w=6 l=2
+  ad=42 pd=26 as=0 ps=0
M3203 datapath_0/shift_0/shift_one_0[5]/mux2_1/nand2_2/B datapath_0/rx5 Vdd Vdd pfet w=12 l=2
+  ad=84 pd=38 as=0 ps=0
M3204 datapath_0/shift_0/shift_one_0[5]/mux2_1/nand2_2/B datapath_0/shift_0/shift_one_0[5]/mux2_1/nand2_1/B datapath_0/shift_0/shift_one_0[5]/mux2_1/nand2_1/a_7_10# GND nfet w=6 l=2
+  ad=36 pd=24 as=0 ps=0
M3205 Vdd datapath_0/shift_0/shift_one_0[5]/mux2_1/nand2_1/B datapath_0/shift_0/shift_one_0[5]/mux2_1/nand2_2/B Vdd pfet w=12 l=2
+  ad=0 pd=0 as=0 ps=0
M3206 datapath_0/shift_0/shift_one_0[6]/mux2_0/nand2_1/B Vdd GND GND nfet w=5 l=2
+  ad=30 pd=22 as=0 ps=0
M3207 datapath_0/shift_0/shift_one_0[6]/mux2_0/nand2_1/B Vdd Vdd Vdd pfet w=10 l=2
+  ad=60 pd=32 as=0 ps=0
M3208 datapath_0/shift_0/shift_one_0[6]/mux2_0/nand2_0/a_7_10# Vdd GND GND nfet w=6 l=2
+  ad=42 pd=26 as=0 ps=0
M3209 datapath_0/shift_0/shift_one_0[6]/mux2_0/nand2_2/A Vdd Vdd Vdd pfet w=12 l=2
+  ad=84 pd=38 as=0 ps=0
M3210 datapath_0/shift_0/shift_one_0[6]/mux2_0/nand2_2/A datapath_0/rx5 datapath_0/shift_0/shift_one_0[6]/mux2_0/nand2_0/a_7_10# GND nfet w=6 l=2
+  ad=36 pd=24 as=0 ps=0
M3211 Vdd datapath_0/rx5 datapath_0/shift_0/shift_one_0[6]/mux2_0/nand2_2/A Vdd pfet w=12 l=2
+  ad=0 pd=0 as=0 ps=0
M3212 datapath_0/shift_0/shift_one_0[6]/mux2_0/nand2_2/a_7_10# datapath_0/shift_0/shift_one_0[6]/mux2_0/nand2_2/A GND GND nfet w=6 l=2
+  ad=42 pd=26 as=0 ps=0
M3213 datapath_0/shift_0/shift_one_0[6]/mux2_1/B datapath_0/shift_0/shift_one_0[6]/mux2_0/nand2_2/A Vdd Vdd pfet w=12 l=2
+  ad=84 pd=38 as=0 ps=0
M3214 datapath_0/shift_0/shift_one_0[6]/mux2_1/B datapath_0/shift_0/shift_one_0[6]/mux2_0/nand2_2/B datapath_0/shift_0/shift_one_0[6]/mux2_0/nand2_2/a_7_10# GND nfet w=6 l=2
+  ad=36 pd=24 as=0 ps=0
M3215 Vdd datapath_0/shift_0/shift_one_0[6]/mux2_0/nand2_2/B datapath_0/shift_0/shift_one_0[6]/mux2_1/B Vdd pfet w=12 l=2
+  ad=0 pd=0 as=0 ps=0
M3216 datapath_0/shift_0/shift_one_0[6]/mux2_0/nand2_1/a_7_10# datapath_0/rx7 GND GND nfet w=6 l=2
+  ad=42 pd=26 as=0 ps=0
M3217 datapath_0/shift_0/shift_one_0[6]/mux2_0/nand2_2/B datapath_0/rx7 Vdd Vdd pfet w=12 l=2
+  ad=84 pd=38 as=0 ps=0
M3218 datapath_0/shift_0/shift_one_0[6]/mux2_0/nand2_2/B datapath_0/shift_0/shift_one_0[6]/mux2_0/nand2_1/B datapath_0/shift_0/shift_one_0[6]/mux2_0/nand2_1/a_7_10# GND nfet w=6 l=2
+  ad=36 pd=24 as=0 ps=0
M3219 Vdd datapath_0/shift_0/shift_one_0[6]/mux2_0/nand2_1/B datapath_0/shift_0/shift_one_0[6]/mux2_0/nand2_2/B Vdd pfet w=12 l=2
+  ad=0 pd=0 as=0 ps=0
M3220 datapath_0/shift_0/shift_one_0[6]/mux2_1/nand2_1/B Vdd GND GND nfet w=5 l=2
+  ad=30 pd=22 as=0 ps=0
M3221 datapath_0/shift_0/shift_one_0[6]/mux2_1/nand2_1/B Vdd Vdd Vdd pfet w=10 l=2
+  ad=60 pd=32 as=0 ps=0
M3222 datapath_0/shift_0/shift_one_0[6]/mux2_1/nand2_0/a_7_10# Vdd GND GND nfet w=6 l=2
+  ad=42 pd=26 as=0 ps=0
M3223 datapath_0/shift_0/shift_one_0[6]/mux2_1/nand2_2/A Vdd Vdd Vdd pfet w=12 l=2
+  ad=84 pd=38 as=0 ps=0
M3224 datapath_0/shift_0/shift_one_0[6]/mux2_1/nand2_2/A datapath_0/shift_0/shift_one_0[6]/mux2_1/B datapath_0/shift_0/shift_one_0[6]/mux2_1/nand2_0/a_7_10# GND nfet w=6 l=2
+  ad=36 pd=24 as=0 ps=0
M3225 Vdd datapath_0/shift_0/shift_one_0[6]/mux2_1/B datapath_0/shift_0/shift_one_0[6]/mux2_1/nand2_2/A Vdd pfet w=12 l=2
+  ad=0 pd=0 as=0 ps=0
M3226 datapath_0/shift_0/shift_one_0[6]/mux2_1/nand2_2/a_7_10# datapath_0/shift_0/shift_one_0[6]/mux2_1/nand2_2/A GND GND nfet w=6 l=2
+  ad=42 pd=26 as=0 ps=0
M3227 datapath_0/so6 datapath_0/shift_0/shift_one_0[6]/mux2_1/nand2_2/A Vdd Vdd pfet w=12 l=2
+  ad=84 pd=38 as=0 ps=0
M3228 datapath_0/so6 datapath_0/shift_0/shift_one_0[6]/mux2_1/nand2_2/B datapath_0/shift_0/shift_one_0[6]/mux2_1/nand2_2/a_7_10# GND nfet w=6 l=2
+  ad=36 pd=24 as=0 ps=0
M3229 Vdd datapath_0/shift_0/shift_one_0[6]/mux2_1/nand2_2/B datapath_0/so6 Vdd pfet w=12 l=2
+  ad=0 pd=0 as=0 ps=0
M3230 datapath_0/shift_0/shift_one_0[6]/mux2_1/nand2_1/a_7_10# datapath_0/rx6 GND GND nfet w=6 l=2
+  ad=42 pd=26 as=0 ps=0
M3231 datapath_0/shift_0/shift_one_0[6]/mux2_1/nand2_2/B datapath_0/rx6 Vdd Vdd pfet w=12 l=2
+  ad=84 pd=38 as=0 ps=0
M3232 datapath_0/shift_0/shift_one_0[6]/mux2_1/nand2_2/B datapath_0/shift_0/shift_one_0[6]/mux2_1/nand2_1/B datapath_0/shift_0/shift_one_0[6]/mux2_1/nand2_1/a_7_10# GND nfet w=6 l=2
+  ad=36 pd=24 as=0 ps=0
M3233 Vdd datapath_0/shift_0/shift_one_0[6]/mux2_1/nand2_1/B datapath_0/shift_0/shift_one_0[6]/mux2_1/nand2_2/B Vdd pfet w=12 l=2
+  ad=0 pd=0 as=0 ps=0
M3234 datapath_0/shift_0/shift_one_0[7]/mux2_0/nand2_1/B Vdd GND GND nfet w=5 l=2
+  ad=30 pd=22 as=0 ps=0
M3235 datapath_0/shift_0/shift_one_0[7]/mux2_0/nand2_1/B Vdd Vdd Vdd pfet w=10 l=2
+  ad=60 pd=32 as=0 ps=0
M3236 datapath_0/shift_0/shift_one_0[7]/mux2_0/nand2_0/a_7_10# Vdd GND GND nfet w=6 l=2
+  ad=42 pd=26 as=0 ps=0
M3237 datapath_0/shift_0/shift_one_0[7]/mux2_0/nand2_2/A Vdd Vdd Vdd pfet w=12 l=2
+  ad=84 pd=38 as=0 ps=0
M3238 datapath_0/shift_0/shift_one_0[7]/mux2_0/nand2_2/A datapath_0/rx6 datapath_0/shift_0/shift_one_0[7]/mux2_0/nand2_0/a_7_10# GND nfet w=6 l=2
+  ad=36 pd=24 as=0 ps=0
M3239 Vdd datapath_0/rx6 datapath_0/shift_0/shift_one_0[7]/mux2_0/nand2_2/A Vdd pfet w=12 l=2
+  ad=0 pd=0 as=0 ps=0
M3240 datapath_0/shift_0/shift_one_0[7]/mux2_0/nand2_2/a_7_10# datapath_0/shift_0/shift_one_0[7]/mux2_0/nand2_2/A GND GND nfet w=6 l=2
+  ad=42 pd=26 as=0 ps=0
M3241 datapath_0/shift_0/shift_one_0[7]/mux2_1/B datapath_0/shift_0/shift_one_0[7]/mux2_0/nand2_2/A Vdd Vdd pfet w=12 l=2
+  ad=84 pd=38 as=0 ps=0
M3242 datapath_0/shift_0/shift_one_0[7]/mux2_1/B datapath_0/shift_0/shift_one_0[7]/mux2_0/nand2_2/B datapath_0/shift_0/shift_one_0[7]/mux2_0/nand2_2/a_7_10# GND nfet w=6 l=2
+  ad=36 pd=24 as=0 ps=0
M3243 Vdd datapath_0/shift_0/shift_one_0[7]/mux2_0/nand2_2/B datapath_0/shift_0/shift_one_0[7]/mux2_1/B Vdd pfet w=12 l=2
+  ad=0 pd=0 as=0 ps=0
M3244 datapath_0/shift_0/shift_one_0[7]/mux2_0/nand2_1/a_7_10# GND GND GND nfet w=6 l=2
+  ad=42 pd=26 as=0 ps=0
M3245 datapath_0/shift_0/shift_one_0[7]/mux2_0/nand2_2/B GND Vdd Vdd pfet w=12 l=2
+  ad=84 pd=38 as=0 ps=0
M3246 datapath_0/shift_0/shift_one_0[7]/mux2_0/nand2_2/B datapath_0/shift_0/shift_one_0[7]/mux2_0/nand2_1/B datapath_0/shift_0/shift_one_0[7]/mux2_0/nand2_1/a_7_10# GND nfet w=6 l=2
+  ad=36 pd=24 as=0 ps=0
M3247 Vdd datapath_0/shift_0/shift_one_0[7]/mux2_0/nand2_1/B datapath_0/shift_0/shift_one_0[7]/mux2_0/nand2_2/B Vdd pfet w=12 l=2
+  ad=0 pd=0 as=0 ps=0
M3248 datapath_0/shift_0/shift_one_0[7]/mux2_1/nand2_1/B Vdd GND GND nfet w=5 l=2
+  ad=30 pd=22 as=0 ps=0
M3249 datapath_0/shift_0/shift_one_0[7]/mux2_1/nand2_1/B Vdd Vdd Vdd pfet w=10 l=2
+  ad=60 pd=32 as=0 ps=0
M3250 datapath_0/shift_0/shift_one_0[7]/mux2_1/nand2_0/a_7_10# Vdd GND GND nfet w=6 l=2
+  ad=42 pd=26 as=0 ps=0
M3251 datapath_0/shift_0/shift_one_0[7]/mux2_1/nand2_2/A Vdd Vdd Vdd pfet w=12 l=2
+  ad=84 pd=38 as=0 ps=0
M3252 datapath_0/shift_0/shift_one_0[7]/mux2_1/nand2_2/A datapath_0/shift_0/shift_one_0[7]/mux2_1/B datapath_0/shift_0/shift_one_0[7]/mux2_1/nand2_0/a_7_10# GND nfet w=6 l=2
+  ad=36 pd=24 as=0 ps=0
M3253 Vdd datapath_0/shift_0/shift_one_0[7]/mux2_1/B datapath_0/shift_0/shift_one_0[7]/mux2_1/nand2_2/A Vdd pfet w=12 l=2
+  ad=0 pd=0 as=0 ps=0
M3254 datapath_0/shift_0/shift_one_0[7]/mux2_1/nand2_2/a_7_10# datapath_0/shift_0/shift_one_0[7]/mux2_1/nand2_2/A GND GND nfet w=6 l=2
+  ad=42 pd=26 as=0 ps=0
M3255 datapath_0/so7 datapath_0/shift_0/shift_one_0[7]/mux2_1/nand2_2/A Vdd Vdd pfet w=12 l=2
+  ad=84 pd=38 as=0 ps=0
M3256 datapath_0/so7 datapath_0/shift_0/shift_one_0[7]/mux2_1/nand2_2/B datapath_0/shift_0/shift_one_0[7]/mux2_1/nand2_2/a_7_10# GND nfet w=6 l=2
+  ad=36 pd=24 as=0 ps=0
M3257 Vdd datapath_0/shift_0/shift_one_0[7]/mux2_1/nand2_2/B datapath_0/so7 Vdd pfet w=12 l=2
+  ad=0 pd=0 as=0 ps=0
M3258 datapath_0/shift_0/shift_one_0[7]/mux2_1/nand2_1/a_7_10# datapath_0/rx7 GND GND nfet w=6 l=2
+  ad=42 pd=26 as=0 ps=0
M3259 datapath_0/shift_0/shift_one_0[7]/mux2_1/nand2_2/B datapath_0/rx7 Vdd Vdd pfet w=12 l=2
+  ad=84 pd=38 as=0 ps=0
M3260 datapath_0/shift_0/shift_one_0[7]/mux2_1/nand2_2/B datapath_0/shift_0/shift_one_0[7]/mux2_1/nand2_1/B datapath_0/shift_0/shift_one_0[7]/mux2_1/nand2_1/a_7_10# GND nfet w=6 l=2
+  ad=36 pd=24 as=0 ps=0
M3261 Vdd datapath_0/shift_0/shift_one_0[7]/mux2_1/nand2_1/B datapath_0/shift_0/shift_one_0[7]/mux2_1/nand2_2/B Vdd pfet w=12 l=2
+  ad=0 pd=0 as=0 ps=0
M3262 datapath_0/staticizer_0/staticizer_one_0[0]/inv_0/out datapath_0/staticizer_0/staticizer_one_0[0]/internal GND GND nfet w=5 l=2
+  ad=60 pd=44 as=0 ps=0
M3263 datapath_0/staticizer_0/staticizer_one_0[0]/inv_0/out datapath_0/staticizer_0/staticizer_one_0[0]/internal Vdd Vdd pfet w=10 l=2
+  ad=120 pd=64 as=0 ps=0
M3264 datapath_0/staticizer_0/staticizer_one_0[0]/internal out0 GND GND nfet w=5 l=2
+  ad=30 pd=22 as=0 ps=0
M3265 datapath_0/staticizer_0/staticizer_one_0[0]/internal out0 Vdd Vdd pfet w=10 l=2
+  ad=60 pd=32 as=0 ps=0
M3266 datapath_0/staticizer_0/staticizer_one_0[0]/inv_2/out fsm_0/rd GND GND nfet w=5 l=2
+  ad=30 pd=22 as=0 ps=0
M3267 datapath_0/staticizer_0/staticizer_one_0[0]/inv_2/out fsm_0/rd Vdd Vdd pfet w=10 l=2
+  ad=60 pd=32 as=0 ps=0
M3268 GND datapath_0/staticizer_0/staticizer_one_0[0]/inv_2/out datapath_0/staticizer_0/staticizer_one_0[0]/new_latch_0/a_82_52# GND nfet w=5 l=2
+  ad=0 pd=0 as=30 ps=22
M3269 datapath_0/staticizer_0/staticizer_one_0[0]/new_latch_0/a_99_34# datapath_0/staticizer_0/staticizer_one_0[0]/new_latch_0/a_79_32# Vdd Vdd pfet w=10 l=2
+  ad=40 pd=28 as=0 ps=0
M3270 datapath_0/staticizer_0/staticizer_one_0[0]/new_latch_0/a_79_32# out0 Vdd Vdd pfet w=10 l=2
+  ad=60 pd=32 as=0 ps=0
M3271 datapath_0/staticizer_0/staticizer_one_0[0]/inv_0/out datapath_0/staticizer_0/staticizer_one_0[0]/new_latch_0/a_82_52# datapath_0/staticizer_0/staticizer_one_0[0]/new_latch_0/a_99_34# Vdd pfet w=10 l=2
+  ad=0 pd=0 as=0 ps=0
M3272 datapath_0/staticizer_0/staticizer_one_0[0]/new_latch_0/a_82_34# datapath_0/staticizer_0/staticizer_one_0[0]/new_latch_0/a_79_32# GND GND nfet w=5 l=2
+  ad=20 pd=18 as=0 ps=0
M3273 datapath_0/staticizer_0/staticizer_one_0[0]/new_latch_0/a_79_32# out0 GND GND nfet w=5 l=2
+  ad=30 pd=22 as=0 ps=0
M3274 datapath_0/staticizer_0/staticizer_one_0[0]/inv_0/out datapath_0/staticizer_0/staticizer_one_0[0]/inv_2/out datapath_0/staticizer_0/staticizer_one_0[0]/new_latch_0/a_82_34# GND nfet w=5 l=2
+  ad=0 pd=0 as=0 ps=0
M3275 Vdd datapath_0/staticizer_0/staticizer_one_0[0]/inv_2/out datapath_0/staticizer_0/staticizer_one_0[0]/new_latch_0/a_82_52# Vdd pfet w=10 l=2
+  ad=0 pd=0 as=60 ps=32
M3276 datapath_0/staticizer_0/staticizer_one_0[1]/inv_0/out datapath_0/staticizer_0/staticizer_one_0[1]/internal GND GND nfet w=5 l=2
+  ad=60 pd=44 as=0 ps=0
M3277 datapath_0/staticizer_0/staticizer_one_0[1]/inv_0/out datapath_0/staticizer_0/staticizer_one_0[1]/internal Vdd Vdd pfet w=10 l=2
+  ad=120 pd=64 as=0 ps=0
M3278 datapath_0/staticizer_0/staticizer_one_0[1]/internal out1 GND GND nfet w=5 l=2
+  ad=30 pd=22 as=0 ps=0
M3279 datapath_0/staticizer_0/staticizer_one_0[1]/internal out1 Vdd Vdd pfet w=10 l=2
+  ad=60 pd=32 as=0 ps=0
M3280 datapath_0/staticizer_0/staticizer_one_0[1]/inv_2/out fsm_0/rd GND GND nfet w=5 l=2
+  ad=30 pd=22 as=0 ps=0
M3281 datapath_0/staticizer_0/staticizer_one_0[1]/inv_2/out fsm_0/rd Vdd Vdd pfet w=10 l=2
+  ad=60 pd=32 as=0 ps=0
M3282 GND datapath_0/staticizer_0/staticizer_one_0[1]/inv_2/out datapath_0/staticizer_0/staticizer_one_0[1]/new_latch_0/a_82_52# GND nfet w=5 l=2
+  ad=0 pd=0 as=30 ps=22
M3283 datapath_0/staticizer_0/staticizer_one_0[1]/new_latch_0/a_99_34# datapath_0/staticizer_0/staticizer_one_0[1]/new_latch_0/a_79_32# Vdd Vdd pfet w=10 l=2
+  ad=40 pd=28 as=0 ps=0
M3284 datapath_0/staticizer_0/staticizer_one_0[1]/new_latch_0/a_79_32# out1 Vdd Vdd pfet w=10 l=2
+  ad=60 pd=32 as=0 ps=0
M3285 datapath_0/staticizer_0/staticizer_one_0[1]/inv_0/out datapath_0/staticizer_0/staticizer_one_0[1]/new_latch_0/a_82_52# datapath_0/staticizer_0/staticizer_one_0[1]/new_latch_0/a_99_34# Vdd pfet w=10 l=2
+  ad=0 pd=0 as=0 ps=0
M3286 datapath_0/staticizer_0/staticizer_one_0[1]/new_latch_0/a_82_34# datapath_0/staticizer_0/staticizer_one_0[1]/new_latch_0/a_79_32# GND GND nfet w=5 l=2
+  ad=20 pd=18 as=0 ps=0
M3287 datapath_0/staticizer_0/staticizer_one_0[1]/new_latch_0/a_79_32# out1 GND GND nfet w=5 l=2
+  ad=30 pd=22 as=0 ps=0
M3288 datapath_0/staticizer_0/staticizer_one_0[1]/inv_0/out datapath_0/staticizer_0/staticizer_one_0[1]/inv_2/out datapath_0/staticizer_0/staticizer_one_0[1]/new_latch_0/a_82_34# GND nfet w=5 l=2
+  ad=0 pd=0 as=0 ps=0
M3289 Vdd datapath_0/staticizer_0/staticizer_one_0[1]/inv_2/out datapath_0/staticizer_0/staticizer_one_0[1]/new_latch_0/a_82_52# Vdd pfet w=10 l=2
+  ad=0 pd=0 as=60 ps=32
M3290 datapath_0/staticizer_0/staticizer_one_0[2]/inv_0/out datapath_0/staticizer_0/staticizer_one_0[2]/internal GND GND nfet w=5 l=2
+  ad=60 pd=44 as=0 ps=0
M3291 datapath_0/staticizer_0/staticizer_one_0[2]/inv_0/out datapath_0/staticizer_0/staticizer_one_0[2]/internal Vdd Vdd pfet w=10 l=2
+  ad=120 pd=64 as=0 ps=0
M3292 datapath_0/staticizer_0/staticizer_one_0[2]/internal out2 GND GND nfet w=5 l=2
+  ad=30 pd=22 as=0 ps=0
M3293 datapath_0/staticizer_0/staticizer_one_0[2]/internal out2 Vdd Vdd pfet w=10 l=2
+  ad=60 pd=32 as=0 ps=0
M3294 datapath_0/staticizer_0/staticizer_one_0[2]/inv_2/out fsm_0/rd GND GND nfet w=5 l=2
+  ad=30 pd=22 as=0 ps=0
M3295 datapath_0/staticizer_0/staticizer_one_0[2]/inv_2/out fsm_0/rd Vdd Vdd pfet w=10 l=2
+  ad=60 pd=32 as=0 ps=0
M3296 GND datapath_0/staticizer_0/staticizer_one_0[2]/inv_2/out datapath_0/staticizer_0/staticizer_one_0[2]/new_latch_0/a_82_52# GND nfet w=5 l=2
+  ad=0 pd=0 as=30 ps=22
M3297 datapath_0/staticizer_0/staticizer_one_0[2]/new_latch_0/a_99_34# datapath_0/staticizer_0/staticizer_one_0[2]/new_latch_0/a_79_32# Vdd Vdd pfet w=10 l=2
+  ad=40 pd=28 as=0 ps=0
M3298 datapath_0/staticizer_0/staticizer_one_0[2]/new_latch_0/a_79_32# out2 Vdd Vdd pfet w=10 l=2
+  ad=60 pd=32 as=0 ps=0
M3299 datapath_0/staticizer_0/staticizer_one_0[2]/inv_0/out datapath_0/staticizer_0/staticizer_one_0[2]/new_latch_0/a_82_52# datapath_0/staticizer_0/staticizer_one_0[2]/new_latch_0/a_99_34# Vdd pfet w=10 l=2
+  ad=0 pd=0 as=0 ps=0
M3300 datapath_0/staticizer_0/staticizer_one_0[2]/new_latch_0/a_82_34# datapath_0/staticizer_0/staticizer_one_0[2]/new_latch_0/a_79_32# GND GND nfet w=5 l=2
+  ad=20 pd=18 as=0 ps=0
M3301 datapath_0/staticizer_0/staticizer_one_0[2]/new_latch_0/a_79_32# out2 GND GND nfet w=5 l=2
+  ad=30 pd=22 as=0 ps=0
M3302 datapath_0/staticizer_0/staticizer_one_0[2]/inv_0/out datapath_0/staticizer_0/staticizer_one_0[2]/inv_2/out datapath_0/staticizer_0/staticizer_one_0[2]/new_latch_0/a_82_34# GND nfet w=5 l=2
+  ad=0 pd=0 as=0 ps=0
M3303 Vdd datapath_0/staticizer_0/staticizer_one_0[2]/inv_2/out datapath_0/staticizer_0/staticizer_one_0[2]/new_latch_0/a_82_52# Vdd pfet w=10 l=2
+  ad=0 pd=0 as=60 ps=32
M3304 datapath_0/staticizer_0/staticizer_one_0[3]/inv_0/out datapath_0/staticizer_0/staticizer_one_0[3]/internal GND GND nfet w=5 l=2
+  ad=60 pd=44 as=0 ps=0
M3305 datapath_0/staticizer_0/staticizer_one_0[3]/inv_0/out datapath_0/staticizer_0/staticizer_one_0[3]/internal Vdd Vdd pfet w=10 l=2
+  ad=120 pd=64 as=0 ps=0
M3306 datapath_0/staticizer_0/staticizer_one_0[3]/internal out3 GND GND nfet w=5 l=2
+  ad=30 pd=22 as=0 ps=0
M3307 datapath_0/staticizer_0/staticizer_one_0[3]/internal out3 Vdd Vdd pfet w=10 l=2
+  ad=60 pd=32 as=0 ps=0
M3308 datapath_0/staticizer_0/staticizer_one_0[3]/inv_2/out fsm_0/rd GND GND nfet w=5 l=2
+  ad=30 pd=22 as=0 ps=0
M3309 datapath_0/staticizer_0/staticizer_one_0[3]/inv_2/out fsm_0/rd Vdd Vdd pfet w=10 l=2
+  ad=60 pd=32 as=0 ps=0
M3310 GND datapath_0/staticizer_0/staticizer_one_0[3]/inv_2/out datapath_0/staticizer_0/staticizer_one_0[3]/new_latch_0/a_82_52# GND nfet w=5 l=2
+  ad=0 pd=0 as=30 ps=22
M3311 datapath_0/staticizer_0/staticizer_one_0[3]/new_latch_0/a_99_34# datapath_0/staticizer_0/staticizer_one_0[3]/new_latch_0/a_79_32# Vdd Vdd pfet w=10 l=2
+  ad=40 pd=28 as=0 ps=0
M3312 datapath_0/staticizer_0/staticizer_one_0[3]/new_latch_0/a_79_32# out3 Vdd Vdd pfet w=10 l=2
+  ad=60 pd=32 as=0 ps=0
M3313 datapath_0/staticizer_0/staticizer_one_0[3]/inv_0/out datapath_0/staticizer_0/staticizer_one_0[3]/new_latch_0/a_82_52# datapath_0/staticizer_0/staticizer_one_0[3]/new_latch_0/a_99_34# Vdd pfet w=10 l=2
+  ad=0 pd=0 as=0 ps=0
M3314 datapath_0/staticizer_0/staticizer_one_0[3]/new_latch_0/a_82_34# datapath_0/staticizer_0/staticizer_one_0[3]/new_latch_0/a_79_32# GND GND nfet w=5 l=2
+  ad=20 pd=18 as=0 ps=0
M3315 datapath_0/staticizer_0/staticizer_one_0[3]/new_latch_0/a_79_32# out3 GND GND nfet w=5 l=2
+  ad=30 pd=22 as=0 ps=0
M3316 datapath_0/staticizer_0/staticizer_one_0[3]/inv_0/out datapath_0/staticizer_0/staticizer_one_0[3]/inv_2/out datapath_0/staticizer_0/staticizer_one_0[3]/new_latch_0/a_82_34# GND nfet w=5 l=2
+  ad=0 pd=0 as=0 ps=0
M3317 Vdd datapath_0/staticizer_0/staticizer_one_0[3]/inv_2/out datapath_0/staticizer_0/staticizer_one_0[3]/new_latch_0/a_82_52# Vdd pfet w=10 l=2
+  ad=0 pd=0 as=60 ps=32
M3318 datapath_0/staticizer_0/staticizer_one_0[4]/inv_0/out datapath_0/staticizer_0/staticizer_one_0[4]/internal GND GND nfet w=5 l=2
+  ad=60 pd=44 as=0 ps=0
M3319 datapath_0/staticizer_0/staticizer_one_0[4]/inv_0/out datapath_0/staticizer_0/staticizer_one_0[4]/internal Vdd Vdd pfet w=10 l=2
+  ad=120 pd=64 as=0 ps=0
M3320 datapath_0/staticizer_0/staticizer_one_0[4]/internal out4 GND GND nfet w=5 l=2
+  ad=30 pd=22 as=0 ps=0
M3321 datapath_0/staticizer_0/staticizer_one_0[4]/internal out4 Vdd Vdd pfet w=10 l=2
+  ad=60 pd=32 as=0 ps=0
M3322 datapath_0/staticizer_0/staticizer_one_0[4]/inv_2/out fsm_0/rd GND GND nfet w=5 l=2
+  ad=30 pd=22 as=0 ps=0
M3323 datapath_0/staticizer_0/staticizer_one_0[4]/inv_2/out fsm_0/rd Vdd Vdd pfet w=10 l=2
+  ad=60 pd=32 as=0 ps=0
M3324 GND datapath_0/staticizer_0/staticizer_one_0[4]/inv_2/out datapath_0/staticizer_0/staticizer_one_0[4]/new_latch_0/a_82_52# GND nfet w=5 l=2
+  ad=0 pd=0 as=30 ps=22
M3325 datapath_0/staticizer_0/staticizer_one_0[4]/new_latch_0/a_99_34# datapath_0/staticizer_0/staticizer_one_0[4]/new_latch_0/a_79_32# Vdd Vdd pfet w=10 l=2
+  ad=40 pd=28 as=0 ps=0
M3326 datapath_0/staticizer_0/staticizer_one_0[4]/new_latch_0/a_79_32# out4 Vdd Vdd pfet w=10 l=2
+  ad=60 pd=32 as=0 ps=0
M3327 datapath_0/staticizer_0/staticizer_one_0[4]/inv_0/out datapath_0/staticizer_0/staticizer_one_0[4]/new_latch_0/a_82_52# datapath_0/staticizer_0/staticizer_one_0[4]/new_latch_0/a_99_34# Vdd pfet w=10 l=2
+  ad=0 pd=0 as=0 ps=0
M3328 datapath_0/staticizer_0/staticizer_one_0[4]/new_latch_0/a_82_34# datapath_0/staticizer_0/staticizer_one_0[4]/new_latch_0/a_79_32# GND GND nfet w=5 l=2
+  ad=20 pd=18 as=0 ps=0
M3329 datapath_0/staticizer_0/staticizer_one_0[4]/new_latch_0/a_79_32# out4 GND GND nfet w=5 l=2
+  ad=30 pd=22 as=0 ps=0
M3330 datapath_0/staticizer_0/staticizer_one_0[4]/inv_0/out datapath_0/staticizer_0/staticizer_one_0[4]/inv_2/out datapath_0/staticizer_0/staticizer_one_0[4]/new_latch_0/a_82_34# GND nfet w=5 l=2
+  ad=0 pd=0 as=0 ps=0
M3331 Vdd datapath_0/staticizer_0/staticizer_one_0[4]/inv_2/out datapath_0/staticizer_0/staticizer_one_0[4]/new_latch_0/a_82_52# Vdd pfet w=10 l=2
+  ad=0 pd=0 as=60 ps=32
M3332 datapath_0/staticizer_0/staticizer_one_0[5]/inv_0/out datapath_0/staticizer_0/staticizer_one_0[5]/internal GND GND nfet w=5 l=2
+  ad=60 pd=44 as=0 ps=0
M3333 datapath_0/staticizer_0/staticizer_one_0[5]/inv_0/out datapath_0/staticizer_0/staticizer_one_0[5]/internal Vdd Vdd pfet w=10 l=2
+  ad=120 pd=64 as=0 ps=0
M3334 datapath_0/staticizer_0/staticizer_one_0[5]/internal out5 GND GND nfet w=5 l=2
+  ad=30 pd=22 as=0 ps=0
M3335 datapath_0/staticizer_0/staticizer_one_0[5]/internal out5 Vdd Vdd pfet w=10 l=2
+  ad=60 pd=32 as=0 ps=0
M3336 datapath_0/staticizer_0/staticizer_one_0[5]/inv_2/out fsm_0/rd GND GND nfet w=5 l=2
+  ad=30 pd=22 as=0 ps=0
M3337 datapath_0/staticizer_0/staticizer_one_0[5]/inv_2/out fsm_0/rd Vdd Vdd pfet w=10 l=2
+  ad=60 pd=32 as=0 ps=0
M3338 GND datapath_0/staticizer_0/staticizer_one_0[5]/inv_2/out datapath_0/staticizer_0/staticizer_one_0[5]/new_latch_0/a_82_52# GND nfet w=5 l=2
+  ad=0 pd=0 as=30 ps=22
M3339 datapath_0/staticizer_0/staticizer_one_0[5]/new_latch_0/a_99_34# datapath_0/staticizer_0/staticizer_one_0[5]/new_latch_0/a_79_32# Vdd Vdd pfet w=10 l=2
+  ad=40 pd=28 as=0 ps=0
M3340 datapath_0/staticizer_0/staticizer_one_0[5]/new_latch_0/a_79_32# out5 Vdd Vdd pfet w=10 l=2
+  ad=60 pd=32 as=0 ps=0
M3341 datapath_0/staticizer_0/staticizer_one_0[5]/inv_0/out datapath_0/staticizer_0/staticizer_one_0[5]/new_latch_0/a_82_52# datapath_0/staticizer_0/staticizer_one_0[5]/new_latch_0/a_99_34# Vdd pfet w=10 l=2
+  ad=0 pd=0 as=0 ps=0
M3342 datapath_0/staticizer_0/staticizer_one_0[5]/new_latch_0/a_82_34# datapath_0/staticizer_0/staticizer_one_0[5]/new_latch_0/a_79_32# GND GND nfet w=5 l=2
+  ad=20 pd=18 as=0 ps=0
M3343 datapath_0/staticizer_0/staticizer_one_0[5]/new_latch_0/a_79_32# out5 GND GND nfet w=5 l=2
+  ad=30 pd=22 as=0 ps=0
M3344 datapath_0/staticizer_0/staticizer_one_0[5]/inv_0/out datapath_0/staticizer_0/staticizer_one_0[5]/inv_2/out datapath_0/staticizer_0/staticizer_one_0[5]/new_latch_0/a_82_34# GND nfet w=5 l=2
+  ad=0 pd=0 as=0 ps=0
M3345 Vdd datapath_0/staticizer_0/staticizer_one_0[5]/inv_2/out datapath_0/staticizer_0/staticizer_one_0[5]/new_latch_0/a_82_52# Vdd pfet w=10 l=2
+  ad=0 pd=0 as=60 ps=32
M3346 datapath_0/staticizer_0/staticizer_one_0[6]/inv_0/out datapath_0/staticizer_0/staticizer_one_0[6]/internal GND GND nfet w=5 l=2
+  ad=60 pd=44 as=0 ps=0
M3347 datapath_0/staticizer_0/staticizer_one_0[6]/inv_0/out datapath_0/staticizer_0/staticizer_one_0[6]/internal Vdd Vdd pfet w=10 l=2
+  ad=120 pd=64 as=0 ps=0
M3348 datapath_0/staticizer_0/staticizer_one_0[6]/internal out6 GND GND nfet w=5 l=2
+  ad=30 pd=22 as=0 ps=0
M3349 datapath_0/staticizer_0/staticizer_one_0[6]/internal out6 Vdd Vdd pfet w=10 l=2
+  ad=60 pd=32 as=0 ps=0
M3350 datapath_0/staticizer_0/staticizer_one_0[6]/inv_2/out fsm_0/rd GND GND nfet w=5 l=2
+  ad=30 pd=22 as=0 ps=0
M3351 datapath_0/staticizer_0/staticizer_one_0[6]/inv_2/out fsm_0/rd Vdd Vdd pfet w=10 l=2
+  ad=60 pd=32 as=0 ps=0
M3352 GND datapath_0/staticizer_0/staticizer_one_0[6]/inv_2/out datapath_0/staticizer_0/staticizer_one_0[6]/new_latch_0/a_82_52# GND nfet w=5 l=2
+  ad=0 pd=0 as=30 ps=22
M3353 datapath_0/staticizer_0/staticizer_one_0[6]/new_latch_0/a_99_34# datapath_0/staticizer_0/staticizer_one_0[6]/new_latch_0/a_79_32# Vdd Vdd pfet w=10 l=2
+  ad=40 pd=28 as=0 ps=0
M3354 datapath_0/staticizer_0/staticizer_one_0[6]/new_latch_0/a_79_32# out6 Vdd Vdd pfet w=10 l=2
+  ad=60 pd=32 as=0 ps=0
M3355 datapath_0/staticizer_0/staticizer_one_0[6]/inv_0/out datapath_0/staticizer_0/staticizer_one_0[6]/new_latch_0/a_82_52# datapath_0/staticizer_0/staticizer_one_0[6]/new_latch_0/a_99_34# Vdd pfet w=10 l=2
+  ad=0 pd=0 as=0 ps=0
M3356 datapath_0/staticizer_0/staticizer_one_0[6]/new_latch_0/a_82_34# datapath_0/staticizer_0/staticizer_one_0[6]/new_latch_0/a_79_32# GND GND nfet w=5 l=2
+  ad=20 pd=18 as=0 ps=0
M3357 datapath_0/staticizer_0/staticizer_one_0[6]/new_latch_0/a_79_32# out6 GND GND nfet w=5 l=2
+  ad=30 pd=22 as=0 ps=0
M3358 datapath_0/staticizer_0/staticizer_one_0[6]/inv_0/out datapath_0/staticizer_0/staticizer_one_0[6]/inv_2/out datapath_0/staticizer_0/staticizer_one_0[6]/new_latch_0/a_82_34# GND nfet w=5 l=2
+  ad=0 pd=0 as=0 ps=0
M3359 Vdd datapath_0/staticizer_0/staticizer_one_0[6]/inv_2/out datapath_0/staticizer_0/staticizer_one_0[6]/new_latch_0/a_82_52# Vdd pfet w=10 l=2
+  ad=0 pd=0 as=60 ps=32
M3360 datapath_0/staticizer_0/staticizer_one_0[7]/inv_0/out datapath_0/staticizer_0/staticizer_one_0[7]/internal GND GND nfet w=5 l=2
+  ad=60 pd=44 as=0 ps=0
M3361 datapath_0/staticizer_0/staticizer_one_0[7]/inv_0/out datapath_0/staticizer_0/staticizer_one_0[7]/internal Vdd Vdd pfet w=10 l=2
+  ad=120 pd=64 as=0 ps=0
M3362 datapath_0/staticizer_0/staticizer_one_0[7]/internal out7 GND GND nfet w=5 l=2
+  ad=30 pd=22 as=0 ps=0
M3363 datapath_0/staticizer_0/staticizer_one_0[7]/internal out7 Vdd Vdd pfet w=10 l=2
+  ad=60 pd=32 as=0 ps=0
M3364 datapath_0/staticizer_0/staticizer_one_0[7]/inv_2/out fsm_0/rd GND GND nfet w=5 l=2
+  ad=30 pd=22 as=0 ps=0
M3365 datapath_0/staticizer_0/staticizer_one_0[7]/inv_2/out fsm_0/rd Vdd Vdd pfet w=10 l=2
+  ad=60 pd=32 as=0 ps=0
M3366 GND datapath_0/staticizer_0/staticizer_one_0[7]/inv_2/out datapath_0/staticizer_0/staticizer_one_0[7]/new_latch_0/a_82_52# GND nfet w=5 l=2
+  ad=0 pd=0 as=30 ps=22
M3367 datapath_0/staticizer_0/staticizer_one_0[7]/new_latch_0/a_99_34# datapath_0/staticizer_0/staticizer_one_0[7]/new_latch_0/a_79_32# Vdd Vdd pfet w=10 l=2
+  ad=40 pd=28 as=0 ps=0
M3368 datapath_0/staticizer_0/staticizer_one_0[7]/new_latch_0/a_79_32# out7 Vdd Vdd pfet w=10 l=2
+  ad=60 pd=32 as=0 ps=0
M3369 datapath_0/staticizer_0/staticizer_one_0[7]/inv_0/out datapath_0/staticizer_0/staticizer_one_0[7]/new_latch_0/a_82_52# datapath_0/staticizer_0/staticizer_one_0[7]/new_latch_0/a_99_34# Vdd pfet w=10 l=2
+  ad=0 pd=0 as=0 ps=0
M3370 datapath_0/staticizer_0/staticizer_one_0[7]/new_latch_0/a_82_34# datapath_0/staticizer_0/staticizer_one_0[7]/new_latch_0/a_79_32# GND GND nfet w=5 l=2
+  ad=20 pd=18 as=0 ps=0
M3371 datapath_0/staticizer_0/staticizer_one_0[7]/new_latch_0/a_79_32# out7 GND GND nfet w=5 l=2
+  ad=30 pd=22 as=0 ps=0
M3372 datapath_0/staticizer_0/staticizer_one_0[7]/inv_0/out datapath_0/staticizer_0/staticizer_one_0[7]/inv_2/out datapath_0/staticizer_0/staticizer_one_0[7]/new_latch_0/a_82_34# GND nfet w=5 l=2
+  ad=0 pd=0 as=0 ps=0
M3373 Vdd datapath_0/staticizer_0/staticizer_one_0[7]/inv_2/out datapath_0/staticizer_0/staticizer_one_0[7]/new_latch_0/a_82_52# Vdd pfet w=10 l=2
+  ad=0 pd=0 as=60 ps=32
C0 h2 h6 2.31fF
C1 datapath_0/wz1 Vdd 3.90fF
C2 GND fsm_0/reg1w 11.25fF
C3 fsm_0/rfb fsm_0/ros 2.32fF
C4 Vdd datapath_0/g2 2.30fF
C5 Vdd datapath_0/cin 4.99fF
C6 Vdd datapath_0/ry0 4.49fF
C7 datapath_0/ras fsm_0/reg0w 3.07fF
C8 datapath_0/wz2 Vdd 3.90fF
C9 datapath_0/wz6 Vdd 3.90fF
C10 Vdd datapath_0/rx0 4.75fF
C11 GND datapath_0/reg2r1 3.56fF
C12 fsm_0/rd GND 11.29fF
C13 datapath_0/wz7 datapath_0/rx7 3.59fF
C14 datapath_0/rx7 GND 4.10fF
C15 fsm_0/fsm_states_0/_reset nh2 3.50fF
C16 Vdd fsm_0/reg1w 2.71fF
C17 datapath_0/wz3 datapath_0/rx3 3.59fF
C18 GND datapath_0/ry5 2.04fF
C19 Vdd fsm_0/rd 4.19fF
C20 GND datapath_0/reg1r2 3.94fF
C21 GND datapath_0/rx5 4.32fF
C22 fsm_0/reg1r1 GND 4.11fF
C23 GND datapath_0/rx1 4.83fF
C24 Vdd datapath_0/rx7 6.48fF
C25 GND datapath_0/ry3 2.04fF
C26 Vdd datapath_0/ry5 4.03fF
C27 datapath_0/wz7 Vdd 3.80fF
C28 datapath_0/wz6 datapath_0/rx6 3.59fF
C29 Vdd GND 100.20fF
C30 PHI1 GND 3.44fF
C31 GND datapath_0/ry1 2.04fF
C32 datapath_0/wz2 datapath_0/rx2 3.59fF
C33 Vdd datapath_0/rx5 7.00fF
C34 Vdd datapath_0/rx1 7.14fF
C35 Vdd datapath_0/ry3 4.02fF
C36 datapath_0/ras fsm_0/reg1w 2.22fF
C37 fsm_0/ros GND 4.18fF
C38 fsm_0/reg0w fsm_0/reg1w 2.92fF
C39 fsm_0/ld GND 4.17fF
C40 GND datapath_0/rx4 4.32fF
C41 Vdd datapath_0/ry1 4.02fF
C42 datapath_0/wz0 datapath_0/rx0 3.60fF
C43 h2 h4 2.72fF
C44 h2 Vdd 2.29fF
C45 datapath_0/wz4 Vdd 3.90fF
C46 datapath_0/ras GND 4.12fF
C47 GND datapath_0/rx6 4.32fF
C48 Vdd datapath_0/rx4 7.23fF
C49 datapath_0/ry6 GND 2.04fF
C50 GND fsm_0/reg0w 11.23fF
C51 GND datapath_0/rx2 4.32fF
C52 PHI0 GND 3.39fF
C53 datapath_0/wz4 datapath_0/rx4 3.59fF
C54 datapath_0/wz5 datapath_0/rx5 3.59fF
C55 GND fsm_0/reg0r0 3.71fF
C56 GND datapath_0/ry4 2.04fF
C57 GND datapath_0/rx3 4.32fF
C58 datapath_0/wz3 Vdd 3.90fF
C59 Vdd datapath_0/rx6 7.32fF
C60 datapath_0/ry7 Vdd 4.01fF
C61 Vdd datapath_0/ry6 4.02fF
C62 Vdd fsm_0/reg0w 2.51fF
C63 Vdd datapath_0/rx2 7.17fF
C64 fsm_0/rfb GND 4.27fF
C65 GND datapath_0/ry2 2.04fF
C66 datapath_0/wz5 Vdd 3.90fF
C67 datapath_0/or4_0/out GND 7.85fF
C68 Vdd datapath_0/ry4 4.02fF
C69 h6 h4 2.50fF
C70 Vdd datapath_0/rx3 6.93fF
C71 datapath_0/wz1 datapath_0/rx1 3.59fF
C72 GND datapath_0/g2 47.88fF
C73 GND datapath_0/cin 5.64fF
C74 GND datapath_0/ry0 2.31fF
C75 fsm_0/fsm_states_0/_iter GND 2.09fF
C76 datapath_0/wz0 Vdd 4.33fF
C77 GND datapath_0/rx0 3.59fF
C78 Vdd datapath_0/ry2 4.02fF
C79 datapath_0/g2 0 11.70fF
C80 Vdd 0 491.79fF
